{
  clocking:
  [
    {
      clock: clk_i
      reset: rst_n_i
    }
  ]
  bus_interfaces:
  [
    {
      protocol: tlul
      direction: device
    }
  ]
  name: aic_ht_dw_axi_dmac
  regwidth: 64
  regalign: 64
  registers:
  [
    {
      skipto: 0x0
    }
    {
      name: DMAC_IDREG
      fields:
      [
        {
          bits: 31:0
          name: DMAC_ID
          desc: none
          resval: 0x0
          hwaccess: hro
          swaccess: ro
        }
        {
          bits: 63:32
          name: RSVD_DMAC_IDREG
          desc: none
          resval: 0x0
          hwaccess: hro
          swaccess: ro
        }
      ]
      desc: none
      tags:
      [
        exc:CsrBitBashTest
      ]
    }
    {
      skipto: 0x8
    }
    {
      name: DMAC_COMPVERREG
      fields:
      [
        {
          bits: 31:0
          name: DMAC_COMPVER
          desc: none
          resval: 0x3230332a
          hwaccess: hro
          swaccess: ro
        }
        {
          bits: 63:32
          name: RSVD_DMAC_COMPVERREG
          desc: none
          resval: 0x0
          hwaccess: hro
          swaccess: ro
        }
      ]
      desc: none
      tags:
      [
        exc:CsrBitBashTest
      ]
    }
    {
      skipto: 0x10
    }
    {
      name: DMAC_CFGREG
      fields:
      [
        {
          bits: 0:0
          name: DMAC_EN
          desc: none
          resval: 0x0
          hwaccess: hro
          swaccess: rw
        }
        {
          bits: 1:1
          name: INT_EN
          desc: none
          resval: 0x0
          hwaccess: hro
          swaccess: rw
        }
        {
          bits: 63:2
          name: RSVD_DMAC_CFGREG
          desc: none
          resval: 0x0
          hwaccess: hro
          swaccess: ro
        }
      ]
      desc: none
    }
    {
      skipto: 0x18
    }
    {
      name: DMAC_CHENREG
      fields:
      [
        {
          bits: 0:0
          name: CH1_EN
          desc: none
          resval: 0x0
          hwaccess: hrw
          swaccess: rw
        }
        {
          bits: 1:1
          name: CH2_EN
          desc: none
          resval: 0x0
          hwaccess: hrw
          swaccess: rw
        }
        {
          bits: 7:2
          name: RSVD_DMAC_CHENREG_CH_EN
          desc: none
          resval: 0x0
          hwaccess: hrw
          swaccess: ro
        }
        {
          bits: 8:8
          name: CH1_EN_WE
          desc: none
          resval: 0x0
          hwaccess: hrw
          swaccess: wo
        }
        {
          bits: 9:9
          name: CH2_EN_WE
          desc: none
          resval: 0x0
          hwaccess: hrw
          swaccess: wo
        }
        {
          bits: 15:10
          name: RSVD_DMAC_CHENREG_CH_WE_EN
          desc: none
          resval: 0x0
          hwaccess: hrw
          swaccess: ro
        }
        {
          bits: 16:16
          name: CH1_SUSP
          desc: none
          resval: 0x0
          hwaccess: hrw
          swaccess: rw
        }
        {
          bits: 17:17
          name: CH2_SUSP
          desc: none
          resval: 0x0
          hwaccess: hrw
          swaccess: rw
        }
        {
          bits: 23:18
          name: RSVD_DMAC_CHENREG_CH_SUSP
          desc: none
          resval: 0x0
          hwaccess: hrw
          swaccess: ro
        }
        {
          bits: 24:24
          name: CH1_SUSP_WE
          desc: none
          resval: 0x0
          hwaccess: hrw
          swaccess: wo
        }
        {
          bits: 25:25
          name: CH2_SUSP_WE
          desc: none
          resval: 0x0
          hwaccess: hrw
          swaccess: wo
        }
        {
          bits: 31:26
          name: RSVD_DMAC_CHENREG_CH_SUSP_WE
          desc: none
          resval: 0x0
          hwaccess: hrw
          swaccess: ro
        }
        {
          bits: 32:32
          name: CH1_ABORT
          desc: none
          resval: 0x0
          hwaccess: hrw
          swaccess: ro
        }
        {
          bits: 33:33
          name: CH2_ABORT
          desc: none
          resval: 0x0
          hwaccess: hrw
          swaccess: ro
        }
        {
          bits: 39:34
          name: RSVD_DMAC_CHENREG_CH_ABORT
          desc: none
          resval: 0x0
          hwaccess: hrw
          swaccess: ro
        }
        {
          bits: 40:40
          name: CH1_ABORT_WE
          desc: none
          resval: 0x0
          hwaccess: hrw
          swaccess: ro
        }
        {
          bits: 41:41
          name: CH2_ABORT_WE
          desc: none
          resval: 0x0
          hwaccess: hrw
          swaccess: ro
        }
        {
          bits: 47:42
          name: RSVD_DMAC_CHENREG_CH_ABORT_WE
          desc: none
          resval: 0x0
          hwaccess: hrw
          swaccess: ro
        }
        {
          bits: 63:48
          name: RSVD_DMAC_CHENREG
          desc: none
          resval: 0x0
          hwaccess: hrw
          swaccess: ro
        }
      ]
      desc: none
    }
    {
      skipto: 0x30
    }
    {
      name: DMAC_INTSTATUSREG
      fields:
      [
        {
          bits: 0:0
          name: CH1_IntStat
          desc: none
          resval: 0x0
          hwaccess: hrw
          swaccess: ro
        }
        {
          bits: 1:1
          name: CH2_IntStat
          desc: none
          resval: 0x0
          hwaccess: hrw
          swaccess: ro
        }
        {
          bits: 7:2
          name: RSVD_DMAC_INTSTATUSREG_8to1
          desc: none
          resval: 0x0
          hwaccess: hrw
          swaccess: ro
        }
        {
          bits: 15:8
          name: RSVD_DMAC_INTSTATUSREG
          desc: none
          resval: 0x0
          hwaccess: hrw
          swaccess: ro
        }
        {
          bits: 16:16
          name: CommonReg_IntStat
          desc: none
          resval: 0x0
          hwaccess: hrw
          swaccess: ro
        }
        {
          bits: 63:17
          name: RSVD_DMAC_INTSTATUSREG_63to17
          desc: none
          resval: 0x0
          hwaccess: hrw
          swaccess: ro
        }
      ]
      desc: none
      tags:
      [
        exc:CsrBitBashTest
      ]
    }
    {
      skipto: 0x38
    }
    {
      name: DMAC_COMMONREG_INTCLEARREG
      fields:
      [
        {
          bits: 0:0
          name: Clear_SLVIF_CommonReg_DEC_ERR_IntStat
          desc: none
          resval: 0x0
          hwaccess: hro
          swaccess: wo
        }
        {
          bits: 1:1
          name: Clear_SLVIF_CommonReg_WR2RO_ERR_IntStat
          desc: none
          resval: 0x0
          hwaccess: hro
          swaccess: wo
        }
        {
          bits: 2:2
          name: Clear_SLVIF_CommonReg_RD2WO_ERR_IntStat
          desc: none
          resval: 0x0
          hwaccess: hro
          swaccess: wo
        }
        {
          bits: 3:3
          name: Clear_SLVIF_CommonReg_WrOnHold_ERR_IntStat
          desc: none
          resval: 0x0
          hwaccess: hro
          swaccess: wo
        }
        {
          bits: 4:4
          name: RSVD_DMAC_COMMONREG_INTCLEARREG_4
          desc: none
          resval: 0x0
          hwaccess: hro
          swaccess: wo
        }
        {
          bits: 5:5
          name: Clear_REGIF_Timeout_ERR_IntStat
          desc: none
          resval: 0x0
          hwaccess: hro
          swaccess: wo
        }
        {
          bits: 6:6
          name: Clear_REGIF_ADDRPARITY_ERR_IntStat
          desc: none
          resval: 0x0
          hwaccess: hro
          swaccess: wo
        }
        {
          bits: 7:7
          name: Clear_REGIF_WRPARITY_ERR_IntStat
          desc: none
          resval: 0x0
          hwaccess: hro
          swaccess: wo
        }
        {
          bits: 8:8
          name: Clear_SLVIF_UndefinedReg_DEC_ERR_IntStat
          desc: none
          resval: 0x0
          hwaccess: hro
          swaccess: wo
        }
        {
          bits: 9:9
          name: Clear_MXIF1_RCH0_PROT_CorrERR_IntStat
          desc: none
          resval: 0x0
          hwaccess: hro
          swaccess: wo
        }
        {
          bits: 10:10
          name: Clear_MXIF1_RCH0_PROT_UnCorrERR_IntStat
          desc: none
          resval: 0x0
          hwaccess: hro
          swaccess: wo
        }
        {
          bits: 11:11
          name: Clear_MXIF1_RCH1_PROT_CorrERR_IntStat
          desc: none
          resval: 0x0
          hwaccess: hro
          swaccess: wo
        }
        {
          bits: 12:12
          name: Clear_MXIF1_RCH1_PROT_UnCorrERR_IntStat
          desc: none
          resval: 0x0
          hwaccess: hro
          swaccess: wo
        }
        {
          bits: 13:13
          name: Clear_MXIF1_BCH_PROT_CorrERR_IntStat
          desc: none
          resval: 0x0
          hwaccess: hro
          swaccess: wo
        }
        {
          bits: 14:14
          name: Clear_MXIF1_BCH_PROT_UnCorrERR_IntStat
          desc: none
          resval: 0x0
          hwaccess: hro
          swaccess: wo
        }
        {
          bits: 15:15
          name: Clear_MXIF2_RCH0_PROT_CorrERR_IntStat
          desc: none
          resval: 0x0
          hwaccess: hro
          swaccess: wo
        }
        {
          bits: 16:16
          name: Clear_MXIF2_RCH0_PROT_UnCorrERR_IntStat
          desc: none
          resval: 0x0
          hwaccess: hro
          swaccess: wo
        }
        {
          bits: 17:17
          name: Clear_MXIF2_RCH1_PROT_CorrERR_IntStat
          desc: none
          resval: 0x0
          hwaccess: hro
          swaccess: wo
        }
        {
          bits: 18:18
          name: Clear_MXIF2_RCH1_PROT_UnCorrERR_IntStat
          desc: none
          resval: 0x0
          hwaccess: hro
          swaccess: wo
        }
        {
          bits: 19:19
          name: Clear_MXIF2_BCH_PROT_CorrERR_IntStat
          desc: none
          resval: 0x0
          hwaccess: hro
          swaccess: wo
        }
        {
          bits: 20:20
          name: Clear_MXIF2_BCH_PROT_UnCorrERR_IntStat
          desc: none
          resval: 0x0
          hwaccess: hro
          swaccess: wo
        }
        {
          bits: 21:21
          name: Clear_MXIF1_ARCH_PROT_ARREADY_ParErr_IntStat
          desc: none
          resval: 0x0
          hwaccess: hro
          swaccess: wo
        }
        {
          bits: 22:22
          name: Clear_MXIF1_AWCH_PROT_AWREADY_ParErr_IntStat
          desc: none
          resval: 0x0
          hwaccess: hro
          swaccess: wo
        }
        {
          bits: 23:23
          name: Clear_MXIF1_WCH_PROT_WREADY_ParErr_IntStat
          desc: none
          resval: 0x0
          hwaccess: hro
          swaccess: wo
        }
        {
          bits: 24:24
          name: Clear_MXIF1_RCH_PROT_RVALID_ParErr_IntStat
          desc: none
          resval: 0x0
          hwaccess: hro
          swaccess: wo
        }
        {
          bits: 25:25
          name: Clear_MXIF1_BCH_PROT_BVALID_ParErr_IntStat
          desc: none
          resval: 0x0
          hwaccess: hro
          swaccess: wo
        }
        {
          bits: 26:26
          name: Clear_MXIF2_ARCH_PROT_ARREADY_ParErr_IntStat
          desc: none
          resval: 0x0
          hwaccess: hro
          swaccess: wo
        }
        {
          bits: 27:27
          name: Clear_MXIF2_AWCH_PROT_AWREADY_ParErr_IntStat
          desc: none
          resval: 0x0
          hwaccess: hro
          swaccess: wo
        }
        {
          bits: 28:28
          name: Clear_MXIF2_WCH_PROT_WREADY_ParErr_IntStat
          desc: none
          resval: 0x0
          hwaccess: hro
          swaccess: wo
        }
        {
          bits: 29:29
          name: Clear_MXIF2_RCH_PROT_RVALID_ParErr_IntStat
          desc: none
          resval: 0x0
          hwaccess: hro
          swaccess: wo
        }
        {
          bits: 30:30
          name: Clear_MXIF2_BCH_PROT_BVALID_ParErr_IntStat
          desc: none
          resval: 0x0
          hwaccess: hro
          swaccess: wo
        }
        {
          bits: 31:31
          name: Clear_MXIF1_ARCH_PROT_Timeout_ERR_IntStat
          desc: none
          resval: 0x0
          hwaccess: hro
          swaccess: wo
        }
        {
          bits: 32:32
          name: Clear_MXIF1_AWCH_PROT_Timeout_ERR_IntStat
          desc: none
          resval: 0x0
          hwaccess: hro
          swaccess: wo
        }
        {
          bits: 33:33
          name: Clear_MXIF1_WCH_PROT_Timeout_ERR_IntStat
          desc: none
          resval: 0x0
          hwaccess: hro
          swaccess: wo
        }
        {
          bits: 34:34
          name: Clear_MXIF1_RCH_PROT_Timeout_ERR_IntStat
          desc: none
          resval: 0x0
          hwaccess: hro
          swaccess: wo
        }
        {
          bits: 35:35
          name: Clear_MXIF1_BCH_PROT_Timeout_ERR_IntStat
          desc: none
          resval: 0x0
          hwaccess: hro
          swaccess: wo
        }
        {
          bits: 36:36
          name: Clear_MXIF2_ARCH_PROT_Timeout_ERR_IntStat
          desc: none
          resval: 0x0
          hwaccess: hro
          swaccess: wo
        }
        {
          bits: 37:37
          name: Clear_MXIF2_AWCH_PROT_Timeout_ERR_IntStat
          desc: none
          resval: 0x0
          hwaccess: hro
          swaccess: wo
        }
        {
          bits: 38:38
          name: Clear_MXIF2_WCH_PROT_Timeout_ERR_IntStat
          desc: none
          resval: 0x0
          hwaccess: hro
          swaccess: wo
        }
        {
          bits: 39:39
          name: Clear_MXIF2_RCH_PROT_Timeout_ERR_IntStat
          desc: none
          resval: 0x0
          hwaccess: hro
          swaccess: wo
        }
        {
          bits: 40:40
          name: Clear_MXIF2_BCH_PROT_Timeout_ERR_IntStat
          desc: none
          resval: 0x0
          hwaccess: hro
          swaccess: wo
        }
        {
          bits: 63:41
          name: RSVD_DMAC_COMMONREG_INTCLEARREG_63to41
          desc: none
          resval: 0x0
          hwaccess: hro
          swaccess: wo
        }
      ]
      desc: none
      tags:
      [
        exc:CsrAllTests
      ]
    }
    {
      skipto: 0x40
    }
    {
      name: DMAC_COMMONREG_INTSTATUS_ENABLEREG
      fields:
      [
        {
          bits: 0:0
          name: Enable_SLVIF_CommonReg_DEC_ERR_IntStat
          desc: none
          resval: 0x1
          hwaccess: hro
          swaccess: rw
        }
        {
          bits: 1:1
          name: Enable_SLVIF_CommonReg_WR2RO_ERR_IntStat
          desc: none
          resval: 0x1
          hwaccess: hro
          swaccess: rw
        }
        {
          bits: 2:2
          name: Enable_SLVIF_CommonReg_RD2WO_ERR_IntStat
          desc: none
          resval: 0x1
          hwaccess: hro
          swaccess: rw
        }
        {
          bits: 3:3
          name: Enable_SLVIF_CommonReg_WrOnHold_ERR_IntStat
          desc: none
          resval: 0x1
          hwaccess: hro
          swaccess: rw
        }
        {
          bits: 4:4
          name: RSVD_DMAC_COMMONREG_INTSTATUS_ENABLEREG_4
          desc: none
          resval: 0x1
          hwaccess: hro
          swaccess: ro
        }
        {
          bits: 5:5
          name: Enable_REGIF_Timeout_ERR_IntStat
          desc: none
          resval: 0x1
          hwaccess: hro
          swaccess: ro
        }
        {
          bits: 6:6
          name: Enable_REGIF_ADDRPARITY_ERR_IntStat
          desc: none
          resval: 0x1
          hwaccess: hro
          swaccess: ro
        }
        {
          bits: 7:7
          name: Enable_REGIF_WRPARITY_ERR_IntStat
          desc: none
          resval: 0x1
          hwaccess: hro
          swaccess: ro
        }
        {
          bits: 8:8
          name: Enable_SLVIF_UndefinedReg_DEC_ERR_IntStat
          desc: none
          resval: 0x1
          hwaccess: hro
          swaccess: rw
        }
        {
          bits: 9:9
          name: Enable_MXIF1_RCH0_PROT_CorrERR_IntStat
          desc: none
          resval: 0x1
          hwaccess: hro
          swaccess: ro
        }
        {
          bits: 10:10
          name: Enable_MXIF1_RCH0_PROT_UnCorrERR_IntStat
          desc: none
          resval: 0x1
          hwaccess: hro
          swaccess: ro
        }
        {
          bits: 11:11
          name: Enable_MXIF1_RCH1_PROT_CorrERR_IntStat
          desc: none
          resval: 0x1
          hwaccess: hro
          swaccess: ro
        }
        {
          bits: 12:12
          name: Enable_MXIF1_RCH1_PROT_UnCorrERR_IntStat
          desc: none
          resval: 0x1
          hwaccess: hro
          swaccess: ro
        }
        {
          bits: 13:13
          name: Enable_MXIF1_BCH_PROT_CorrERR_IntStat
          desc: none
          resval: 0x1
          hwaccess: hro
          swaccess: ro
        }
        {
          bits: 14:14
          name: Enable_MXIF1_BCH_PROT_UnCorrERR_IntStat
          desc: none
          resval: 0x1
          hwaccess: hro
          swaccess: ro
        }
        {
          bits: 15:15
          name: Enable_MXIF2_RCH0_PROT_CorrERR_IntStat
          desc: none
          resval: 0x1
          hwaccess: hro
          swaccess: ro
        }
        {
          bits: 16:16
          name: Enable_MXIF2_RCH0_PROT_UnCorrERR_IntStat
          desc: none
          resval: 0x1
          hwaccess: hro
          swaccess: ro
        }
        {
          bits: 17:17
          name: Enable_MXIF2_RCH1_PROT_CorrERR_IntStat
          desc: none
          resval: 0x1
          hwaccess: hro
          swaccess: ro
        }
        {
          bits: 18:18
          name: Enable_MXIF2_RCH1_PROT_UnCorrERR_IntStat
          desc: none
          resval: 0x1
          hwaccess: hro
          swaccess: ro
        }
        {
          bits: 19:19
          name: Enable_MXIF2_BCH_PROT_CorrERR_IntStat
          desc: none
          resval: 0x1
          hwaccess: hro
          swaccess: ro
        }
        {
          bits: 20:20
          name: Enable_MXIF2_BCH_PROT_UnCorrERR_IntStat
          desc: none
          resval: 0x1
          hwaccess: hro
          swaccess: ro
        }
        {
          bits: 21:21
          name: Enable_MXIF1_ARCH_PROT_ARREADY_ParErr_IntStat
          desc: none
          resval: 0x1
          hwaccess: hro
          swaccess: ro
        }
        {
          bits: 22:22
          name: Enable_MXIF1_AWCH_PROT_AWREADY_ParErr_IntStat
          desc: none
          resval: 0x1
          hwaccess: hro
          swaccess: ro
        }
        {
          bits: 23:23
          name: Enable_MXIF1_WCH_PROT_WREADY_ParErr_IntStat
          desc: none
          resval: 0x1
          hwaccess: hro
          swaccess: ro
        }
        {
          bits: 24:24
          name: Enable_MXIF1_RCH_PROT_RVALID_ParErr_IntStat
          desc: none
          resval: 0x1
          hwaccess: hro
          swaccess: ro
        }
        {
          bits: 25:25
          name: Enable_MXIF1_BCH_PROT_BVALID_ParErr_IntStat
          desc: none
          resval: 0x1
          hwaccess: hro
          swaccess: ro
        }
        {
          bits: 26:26
          name: Enable_MXIF2_ARCH_PROT_ARREADY_ParErr_IntStat
          desc: none
          resval: 0x1
          hwaccess: hro
          swaccess: ro
        }
        {
          bits: 27:27
          name: Enable_MXIF2_AWCH_PROT_AWREADY_ParErr_IntStat
          desc: none
          resval: 0x1
          hwaccess: hro
          swaccess: ro
        }
        {
          bits: 28:28
          name: Enable_MXIF2_WCH_PROT_WREADY_ParErr_IntStat
          desc: none
          resval: 0x1
          hwaccess: hro
          swaccess: ro
        }
        {
          bits: 29:29
          name: Enable_MXIF2_RCH_PROT_RVALID_ParErr_IntStat
          desc: none
          resval: 0x1
          hwaccess: hro
          swaccess: ro
        }
        {
          bits: 30:30
          name: Enable_MXIF2_BCH_PROT_BVALID_ParErr_IntStat
          desc: none
          resval: 0x1
          hwaccess: hro
          swaccess: ro
        }
        {
          bits: 31:31
          name: Enable_MXIF1_ARCH_PROT_Timeout_ERR_IntStat
          desc: none
          resval: 0x1
          hwaccess: hro
          swaccess: ro
        }
        {
          bits: 32:32
          name: Enable_MXIF1_AWCH_PROT_Timeout_ERR_IntStat
          desc: none
          resval: 0x1
          hwaccess: hro
          swaccess: ro
        }
        {
          bits: 33:33
          name: Enable_MXIF1_WCH_PROT_Timeout_ERR_IntStat
          desc: none
          resval: 0x1
          hwaccess: hro
          swaccess: ro
        }
        {
          bits: 34:34
          name: Enable_MXIF1_RCH_PROT_Timeout_ERR_IntStat
          desc: none
          resval: 0x1
          hwaccess: hro
          swaccess: ro
        }
        {
          bits: 35:35
          name: Enable_MXIF1_BCH_PROT_Timeout_ERR_IntStat
          desc: none
          resval: 0x1
          hwaccess: hro
          swaccess: ro
        }
        {
          bits: 36:36
          name: Enable_MXIF2_ARCH_PROT_Timeout_ERR_IntStat
          desc: none
          resval: 0x1
          hwaccess: hro
          swaccess: ro
        }
        {
          bits: 37:37
          name: Enable_MXIF2_AWCH_PROT_Timeout_ERR_IntStat
          desc: none
          resval: 0x1
          hwaccess: hro
          swaccess: ro
        }
        {
          bits: 38:38
          name: Enable_MXIF2_WCH_PROT_Timeout_ERR_IntStat
          desc: none
          resval: 0x1
          hwaccess: hro
          swaccess: ro
        }
        {
          bits: 39:39
          name: Enable_MXIF2_RCH_PROT_Timeout_ERR_IntStat
          desc: none
          resval: 0x1
          hwaccess: hro
          swaccess: ro
        }
        {
          bits: 40:40
          name: Enable_MXIF2_BCH_PROT_Timeout_ERR_IntStat
          desc: none
          resval: 0x1
          hwaccess: hro
          swaccess: ro
        }
        {
          bits: 63:41
          name: RSVD_DMAC_COMMONREG_INTSTATUS_ENABLEREG_63to41
          desc: none
          resval: 0x7fffff
          hwaccess: hro
          swaccess: ro
        }
      ]
      desc: none
    }
    {
      skipto: 0x48
    }
    {
      name: DMAC_COMMONREG_INTSIGNAL_ENABLEREG
      fields:
      [
        {
          bits: 0:0
          name: Enable_SLVIF_CommonReg_DEC_ERR_IntSignal
          desc: none
          resval: 0x1
          hwaccess: hro
          swaccess: rw
        }
        {
          bits: 1:1
          name: Enable_SLVIF_CommonReg_WR2RO_ERR_IntSignal
          desc: none
          resval: 0x1
          hwaccess: hro
          swaccess: rw
        }
        {
          bits: 2:2
          name: Enable_SLVIF_CommonReg_RD2WO_ERR_IntSignal
          desc: none
          resval: 0x1
          hwaccess: hro
          swaccess: rw
        }
        {
          bits: 3:3
          name: Enable_SLVIF_CommonReg_WrOnHold_ERR_IntSignal
          desc: none
          resval: 0x1
          hwaccess: hro
          swaccess: rw
        }
        {
          bits: 4:4
          name: RSVD_DMAC_COMMONREG_INTSIGNAL_ENABLEREG_4
          desc: none
          resval: 0x1
          hwaccess: hro
          swaccess: ro
        }
        {
          bits: 5:5
          name: Enable_REGIF_Timeout_ERR_IntSignal
          desc: none
          resval: 0x1
          hwaccess: hro
          swaccess: ro
        }
        {
          bits: 6:6
          name: Enable_REGIF_ADDRPARITY_ERR_IntSignal
          desc: none
          resval: 0x1
          hwaccess: hro
          swaccess: ro
        }
        {
          bits: 7:7
          name: Enable_REGIF_WRPARITY_ERR_IntSignal
          desc: none
          resval: 0x1
          hwaccess: hro
          swaccess: ro
        }
        {
          bits: 8:8
          name: Enable_SLVIF_UndefinedReg_DEC_ERR_IntSignal
          desc: none
          resval: 0x1
          hwaccess: hro
          swaccess: rw
        }
        {
          bits: 9:9
          name: Enable_MXIF1_RCH0_PROT_CorrERR_IntSignal
          desc: none
          resval: 0x1
          hwaccess: hro
          swaccess: ro
        }
        {
          bits: 10:10
          name: Enable_MXIF1_RCH0_PROT_UnCorrERR_IntSignal
          desc: none
          resval: 0x1
          hwaccess: hro
          swaccess: ro
        }
        {
          bits: 11:11
          name: Enable_MXIF1_RCH1_PROT_CorrERR_IntSignal
          desc: none
          resval: 0x1
          hwaccess: hro
          swaccess: ro
        }
        {
          bits: 12:12
          name: Enable_MXIF1_RCH1_PROT_UnCorrERR_IntSignal
          desc: none
          resval: 0x1
          hwaccess: hro
          swaccess: ro
        }
        {
          bits: 13:13
          name: Enable_MXIF1_BCH_PROT_CorrERR_IntSignal
          desc: none
          resval: 0x1
          hwaccess: hro
          swaccess: ro
        }
        {
          bits: 14:14
          name: Enable_MXIF1_BCH_PROT_UnCorrERR_IntSignal
          desc: none
          resval: 0x1
          hwaccess: hro
          swaccess: ro
        }
        {
          bits: 15:15
          name: Enable_MXIF2_RCH0_PROT_CorrERR_IntSignal
          desc: none
          resval: 0x1
          hwaccess: hro
          swaccess: ro
        }
        {
          bits: 16:16
          name: Enable_MXIF2_RCH0_PROT_UnCorrERR_IntSignal
          desc: none
          resval: 0x1
          hwaccess: hro
          swaccess: ro
        }
        {
          bits: 17:17
          name: Enable_MXIF2_RCH1_PROT_CorrERR_IntSignal
          desc: none
          resval: 0x1
          hwaccess: hro
          swaccess: ro
        }
        {
          bits: 18:18
          name: Enable_MXIF2_RCH1_PROT_UnCorrERR_IntSignal
          desc: none
          resval: 0x1
          hwaccess: hro
          swaccess: ro
        }
        {
          bits: 19:19
          name: Enable_MXIF2_BCH_PROT_CorrERR_IntSignal
          desc: none
          resval: 0x1
          hwaccess: hro
          swaccess: ro
        }
        {
          bits: 20:20
          name: Enable_MXIF2_BCH_PROT_UnCorrERR_IntSignal
          desc: none
          resval: 0x1
          hwaccess: hro
          swaccess: ro
        }
        {
          bits: 21:21
          name: Enable_MXIF1_ARCH_PROT_ARREADY_ParErr_IntSignal
          desc: none
          resval: 0x1
          hwaccess: hro
          swaccess: ro
        }
        {
          bits: 22:22
          name: Enable_MXIF1_AWCH_PROT_AWREADY_ParErr_IntSignal
          desc: none
          resval: 0x1
          hwaccess: hro
          swaccess: ro
        }
        {
          bits: 23:23
          name: Enable_MXIF1_WCH_PROT_WREADY_ParErr_IntSignal
          desc: none
          resval: 0x1
          hwaccess: hro
          swaccess: ro
        }
        {
          bits: 24:24
          name: Enable_MXIF1_RCH_PROT_RVALID_ParErr_IntSignal
          desc: none
          resval: 0x1
          hwaccess: hro
          swaccess: ro
        }
        {
          bits: 25:25
          name: Enable_MXIF1_BCH_PROT_BVALID_ParErr_IntSignal
          desc: none
          resval: 0x1
          hwaccess: hro
          swaccess: ro
        }
        {
          bits: 26:26
          name: Enable_MXIF2_ARCH_PROT_ARREADY_ParErr_IntSignal
          desc: none
          resval: 0x1
          hwaccess: hro
          swaccess: ro
        }
        {
          bits: 27:27
          name: Enable_MXIF2_AWCH_PROT_AWREADY_ParErr_IntSignal
          desc: none
          resval: 0x1
          hwaccess: hro
          swaccess: ro
        }
        {
          bits: 28:28
          name: Enable_MXIF2_WCH_PROT_WREADY_ParErr_IntSignal
          desc: none
          resval: 0x1
          hwaccess: hro
          swaccess: ro
        }
        {
          bits: 29:29
          name: Enable_MXIF2_RCH_PROT_RVALID_ParErr_IntSignal
          desc: none
          resval: 0x1
          hwaccess: hro
          swaccess: ro
        }
        {
          bits: 30:30
          name: Enable_MXIF2_BCH_PROT_BVALID_ParErr_IntSignal
          desc: none
          resval: 0x1
          hwaccess: hro
          swaccess: ro
        }
        {
          bits: 31:31
          name: Enable_MXIF1_ARCH_PROT_Timeout_ERR_IntSignal
          desc: none
          resval: 0x1
          hwaccess: hro
          swaccess: ro
        }
        {
          bits: 32:32
          name: Enable_MXIF1_AWCH_PROT_Timeout_ERR_IntSignal
          desc: none
          resval: 0x1
          hwaccess: hro
          swaccess: ro
        }
        {
          bits: 33:33
          name: Enable_MXIF1_WCH_PROT_Timeout_ERR_IntSignal
          desc: none
          resval: 0x1
          hwaccess: hro
          swaccess: ro
        }
        {
          bits: 34:34
          name: Enable_MXIF1_RCH_PROT_Timeout_ERR_IntSignal
          desc: none
          resval: 0x1
          hwaccess: hro
          swaccess: ro
        }
        {
          bits: 35:35
          name: Enable_MXIF1_BCH_PROT_Timeout_ERR_IntSignal
          desc: none
          resval: 0x1
          hwaccess: hro
          swaccess: ro
        }
        {
          bits: 36:36
          name: Enable_MXIF2_ARCH_PROT_Timeout_ERR_IntSignal
          desc: none
          resval: 0x1
          hwaccess: hro
          swaccess: ro
        }
        {
          bits: 37:37
          name: Enable_MXIF2_AWCH_PROT_Timeout_ERR_IntSignal
          desc: none
          resval: 0x1
          hwaccess: hro
          swaccess: ro
        }
        {
          bits: 38:38
          name: Enable_MXIF2_WCH_PROT_Timeout_ERR_IntSignal
          desc: none
          resval: 0x1
          hwaccess: hro
          swaccess: ro
        }
        {
          bits: 39:39
          name: Enable_MXIF2_RCH_PROT_Timeout_ERR_IntSignal
          desc: none
          resval: 0x1
          hwaccess: hro
          swaccess: ro
        }
        {
          bits: 40:40
          name: Enable_MXIF2_BCH_PROT_Timeout_ERR_IntSignal
          desc: none
          resval: 0x1
          hwaccess: hro
          swaccess: ro
        }
        {
          bits: 63:41
          name: RSVD_DMAC_COMMONREG_INTSIGNAL_ENABLEREG_63to41
          desc: none
          resval: 0x7fffff
          hwaccess: hro
          swaccess: ro
        }
      ]
      desc: none
    }
    {
      skipto: 0x50
    }
    {
      name: DMAC_COMMONREG_INTSTATUSREG
      fields:
      [
        {
          bits: 0:0
          name: SLVIF_CommonReg_DEC_ERR_IntStat
          desc: none
          resval: 0x0
          hwaccess: hrw
          swaccess: ro
        }
        {
          bits: 1:1
          name: SLVIF_CommonReg_WR2RO_ERR_IntStat
          desc: none
          resval: 0x0
          hwaccess: hrw
          swaccess: ro
        }
        {
          bits: 2:2
          name: SLVIF_CommonReg_RD2WO_ERR_IntStat
          desc: none
          resval: 0x0
          hwaccess: hrw
          swaccess: ro
        }
        {
          bits: 3:3
          name: SLVIF_CommonReg_WrOnHold_ERR_IntStat
          desc: none
          resval: 0x0
          hwaccess: hrw
          swaccess: ro
        }
        {
          bits: 4:4
          name: RSVD_DMAC_COMMONREG_INTSTATUSREG_4
          desc: none
          resval: 0x0
          hwaccess: hrw
          swaccess: ro
        }
        {
          bits: 5:5
          name: REGIF_Timeout_ERR_IntStat
          desc: none
          resval: 0x0
          hwaccess: hrw
          swaccess: ro
        }
        {
          bits: 6:6
          name: REGIF_ADDRPARITY_ERR_IntStat
          desc: none
          resval: 0x0
          hwaccess: hrw
          swaccess: ro
        }
        {
          bits: 7:7
          name: REGIF_WRPARITY_ERR_IntStat
          desc: none
          resval: 0x0
          hwaccess: hrw
          swaccess: ro
        }
        {
          bits: 8:8
          name: SLVIF_UndefinedReg_DEC_ERR_IntStat
          desc: none
          resval: 0x0
          hwaccess: hrw
          swaccess: ro
        }
        {
          bits: 9:9
          name: MXIF1_RCH0_PROT_CorrERR_IntStat
          desc: none
          resval: 0x0
          hwaccess: hrw
          swaccess: ro
        }
        {
          bits: 10:10
          name: MXIF1_RCH0_PROT_UnCorrERR_IntStat
          desc: none
          resval: 0x0
          hwaccess: hrw
          swaccess: ro
        }
        {
          bits: 11:11
          name: MXIF1_RCH1_PROT_CorrERR_IntStat
          desc: none
          resval: 0x0
          hwaccess: hrw
          swaccess: ro
        }
        {
          bits: 12:12
          name: MXIF1_RCH1_PROT_UnCorrERR_IntStat
          desc: none
          resval: 0x0
          hwaccess: hrw
          swaccess: ro
        }
        {
          bits: 13:13
          name: MXIF1_BCH_PROT_CorrERR_IntStat
          desc: none
          resval: 0x0
          hwaccess: hrw
          swaccess: ro
        }
        {
          bits: 14:14
          name: MXIF1_BCH_PROT_UnCorrERR_IntStat
          desc: none
          resval: 0x0
          hwaccess: hrw
          swaccess: ro
        }
        {
          bits: 15:15
          name: MXIF2_RCH0_PROT_CorrERR_IntStat
          desc: none
          resval: 0x0
          hwaccess: hrw
          swaccess: ro
        }
        {
          bits: 16:16
          name: MXIF2_RCH0_PROT_UnCorrERR_IntStat
          desc: none
          resval: 0x0
          hwaccess: hrw
          swaccess: ro
        }
        {
          bits: 17:17
          name: MXIF2_RCH1_PROT_CorrERR_IntStat
          desc: none
          resval: 0x0
          hwaccess: hrw
          swaccess: ro
        }
        {
          bits: 18:18
          name: MXIF2_RCH1_PROT_UnCorrERR_IntStat
          desc: none
          resval: 0x0
          hwaccess: hrw
          swaccess: ro
        }
        {
          bits: 19:19
          name: MXIF2_BCH_PROT_CorrERR_IntStat
          desc: none
          resval: 0x0
          hwaccess: hrw
          swaccess: ro
        }
        {
          bits: 20:20
          name: MXIF2_BCH_PROT_UnCorrERR_IntStat
          desc: none
          resval: 0x0
          hwaccess: hrw
          swaccess: ro
        }
        {
          bits: 21:21
          name: MXIF1_ARCH_PROT_ARREADY_ParErr_IntStat
          desc: none
          resval: 0x0
          hwaccess: hrw
          swaccess: ro
        }
        {
          bits: 22:22
          name: MXIF1_AWCH_PROT_AWREADY_ParErr_IntStat
          desc: none
          resval: 0x0
          hwaccess: hrw
          swaccess: ro
        }
        {
          bits: 23:23
          name: MXIF1_WCH_PROT_WREADY_ParErr_IntStat
          desc: none
          resval: 0x0
          hwaccess: hrw
          swaccess: ro
        }
        {
          bits: 24:24
          name: MXIF1_RCH_PROT_RVALID_ParErr_IntStat
          desc: none
          resval: 0x0
          hwaccess: hrw
          swaccess: ro
        }
        {
          bits: 25:25
          name: MXIF1_BCH_PROT_BVALID_ParErr_IntStat
          desc: none
          resval: 0x0
          hwaccess: hrw
          swaccess: ro
        }
        {
          bits: 26:26
          name: MXIF2_ARCH_PROT_ARREADY_ParErr_IntStat
          desc: none
          resval: 0x0
          hwaccess: hrw
          swaccess: ro
        }
        {
          bits: 27:27
          name: MXIF2_AWCH_PROT_AWREADY_ParErr_IntStat
          desc: none
          resval: 0x0
          hwaccess: hrw
          swaccess: ro
        }
        {
          bits: 28:28
          name: MXIF2_WCH_PROT_WREADY_ParErr_IntStat
          desc: none
          resval: 0x0
          hwaccess: hrw
          swaccess: ro
        }
        {
          bits: 29:29
          name: MXIF2_RCH_PROT_RVALID_ParErr_IntStat
          desc: none
          resval: 0x0
          hwaccess: hrw
          swaccess: ro
        }
        {
          bits: 30:30
          name: MXIF2_BCH_PROT_BVALID_ParErr_IntStat
          desc: none
          resval: 0x0
          hwaccess: hrw
          swaccess: ro
        }
        {
          bits: 31:31
          name: MXIF1_ARCH_PROT_Timeout_ERR_IntStat
          desc: none
          resval: 0x0
          hwaccess: hrw
          swaccess: ro
        }
        {
          bits: 32:32
          name: MXIF1_AWCH_PROT_Timeout_ERR_IntStat
          desc: none
          resval: 0x0
          hwaccess: hrw
          swaccess: ro
        }
        {
          bits: 33:33
          name: MXIF1_WCH_PROT_Timeout_ERR_IntStat
          desc: none
          resval: 0x0
          hwaccess: hrw
          swaccess: ro
        }
        {
          bits: 34:34
          name: MXIF1_RCH_PROT_Timeout_ERR_IntStat
          desc: none
          resval: 0x0
          hwaccess: hrw
          swaccess: ro
        }
        {
          bits: 35:35
          name: MXIF1_BCH_PROT_Timeout_ERR_IntStat
          desc: none
          resval: 0x0
          hwaccess: hrw
          swaccess: ro
        }
        {
          bits: 36:36
          name: MXIF2_ARCH_PROT_Timeout_ERR_IntStat
          desc: none
          resval: 0x0
          hwaccess: hrw
          swaccess: ro
        }
        {
          bits: 37:37
          name: MXIF2_AWCH_PROT_Timeout_ERR_IntStat
          desc: none
          resval: 0x0
          hwaccess: hrw
          swaccess: ro
        }
        {
          bits: 38:38
          name: MXIF2_WCH_PROT_Timeout_ERR_IntStat
          desc: none
          resval: 0x0
          hwaccess: hrw
          swaccess: ro
        }
        {
          bits: 39:39
          name: MXIF2_RCH_PROT_Timeout_ERR_IntStat
          desc: none
          resval: 0x0
          hwaccess: hrw
          swaccess: ro
        }
        {
          bits: 40:40
          name: MXIF2_BCH_PROT_Timeout_ERR_IntStat
          desc: none
          resval: 0x0
          hwaccess: hrw
          swaccess: ro
        }
        {
          bits: 63:41
          name: RSVD_DMAC_COMMONREG_INTSTATUSREG_63to41
          desc: none
          resval: 0x0
          hwaccess: hrw
          swaccess: ro
        }
      ]
      desc: none
      tags:
      [
        exc:CsrBitBashTest
      ]
    }
    {
      skipto: 0x58
    }
    {
      name: DMAC_RESETREG
      fields:
      [
        {
          bits: 0:0
          name: DMAC_RST
          desc: none
          resval: 0x0
          hwaccess: hrw
          swaccess: rw
        }
        {
          bits: 1:1
          name: CH_PRIOR_RST
          desc: none
          resval: 0x0
          hwaccess: hrw
          swaccess: rw
        }
        {
          bits: 2:2
          name: VM_ID_RST
          desc: none
          resval: 0x0
          hwaccess: hrw
          swaccess: rw
        }
        {
          bits: 63:3
          name: RSVD_DMAC_ResetReg_3to63
          desc: none
          resval: 0x0
          hwaccess: hrw
          swaccess: ro
        }
      ]
      desc: none
    }
    {
      skipto: 0x60
    }
    {
      name: DMAC_LOWPOWER_CFGREG
      fields:
      [
        {
          bits: 0:0
          name: GBL_CSLP_EN
          desc: none
          resval: 0x1
          hwaccess: hrw
          swaccess: rw
        }
        {
          bits: 1:1
          name: CHNL_CSLP_EN
          desc: none
          resval: 0x1
          hwaccess: hrw
          swaccess: rw
        }
        {
          bits: 2:2
          name: SBIU_CSLP_EN
          desc: none
          resval: 0x1
          hwaccess: hrw
          swaccess: rw
        }
        {
          bits: 3:3
          name: MXIF_CSLP_EN
          desc: none
          resval: 0x1
          hwaccess: hrw
          swaccess: rw
        }
        {
          bits: 31:4
          name: RSVD_DMAC_LOWPOWER_CFGREG_31to4
          desc: none
          resval: 0x0
          hwaccess: hrw
          swaccess: ro
        }
        {
          bits: 39:32
          name: GLCH_LPDLY
          desc: none
          resval: 0x4
          hwaccess: hrw
          swaccess: rw
        }
        {
          bits: 47:40
          name: SBIU_LPDLY
          desc: none
          resval: 0x4
          hwaccess: hrw
          swaccess: rw
        }
        {
          bits: 55:48
          name: MXIF_LPDLY
          desc: none
          resval: 0x4
          hwaccess: hrw
          swaccess: rw
        }
        {
          bits: 63:56
          name: RSVD_DMAC_LOWPOWER_CFGREG_63to56
          desc: none
          resval: 0x0
          hwaccess: hrw
          swaccess: ro
        }
      ]
      desc: none
    }
    {
      skipto: 0x100
    }
    {
      name: CH1_SAR
      fields:
      [
        {
          bits: 63:0
          name: SAR
          desc: none
          resval: 0x0
          hwaccess: hrw
          swaccess: rw
        }
      ]
      desc: none
    }
    {
      skipto: 0x108
    }
    {
      name: CH1_DAR
      fields:
      [
        {
          bits: 63:0
          name: DAR
          desc: none
          resval: 0x0
          hwaccess: hrw
          swaccess: rw
        }
      ]
      desc: none
    }
    {
      skipto: 0x110
    }
    {
      name: CH1_BLOCK_TS
      fields:
      [
        {
          bits: 21:0
          name: BLOCK_TS
          desc: none
          resval: 0x0
          hwaccess: hrw
          swaccess: rw
        }
        {
          bits: 63:22
          name: RSVD_DMAC_CHx_BLOCK_TSREG_63to22
          desc: none
          resval: 0x0
          hwaccess: hrw
          swaccess: ro
        }
      ]
      desc: none
    }
    {
      skipto: 0x118
    }
    {
      name: CH1_CTL
      fields:
      [
        {
          bits: 0:0
          name: SMS
          desc: none
          resval: 0x0
          hwaccess: hro
          swaccess: rw
        }
        {
          bits: 1:1
          name: RSVD_DMAC_CHx_CTL_1
          desc: none
          resval: 0x0
          hwaccess: hro
          swaccess: ro
        }
        {
          bits: 2:2
          name: DMS
          desc: none
          resval: 0x0
          hwaccess: hro
          swaccess: rw
        }
        {
          bits: 3:3
          name: RSVD_DMAC_CHx_CTL_3
          desc: none
          resval: 0x0
          hwaccess: hro
          swaccess: ro
        }
        {
          bits: 4:4
          name: SINC
          desc: none
          resval: 0x0
          hwaccess: hro
          swaccess: rw
        }
        {
          bits: 5:5
          name: RSVD_DMAC_CHx_CTL_5
          desc: none
          resval: 0x0
          hwaccess: hro
          swaccess: ro
        }
        {
          bits: 6:6
          name: DINC
          desc: none
          resval: 0x0
          hwaccess: hro
          swaccess: rw
        }
        {
          bits: 7:7
          name: CRC_EN
          desc: none
          resval: 0x0
          hwaccess: hro
          swaccess: ro
        }
        {
          bits: 10:8
          name: SRC_TR_WIDTH
          desc: none
          resval: 0x2
          hwaccess: hro
          swaccess: rw
        }
        {
          bits: 13:11
          name: DST_TR_WIDTH
          desc: none
          resval: 0x2
          hwaccess: hro
          swaccess: rw
        }
        {
          bits: 17:14
          name: SRC_MSIZE
          desc: none
          resval: 0x0
          hwaccess: hro
          swaccess: rw
        }
        {
          bits: 21:18
          name: DST_MSIZE
          desc: none
          resval: 0x0
          hwaccess: hro
          swaccess: rw
        }
        {
          bits: 25:22
          name: AR_CACHE
          desc: none
          resval: 0x0
          hwaccess: hro
          swaccess: rw
        }
        {
          bits: 29:26
          name: AW_CACHE
          desc: none
          resval: 0x0
          hwaccess: hro
          swaccess: rw
        }
        {
          bits: 30:30
          name: NonPosted_LastWrite_En
          desc: none
          resval: 0x0
          hwaccess: hro
          swaccess: rw
        }
        {
          bits: 31:31
          name: RSVD_DMAC_CHx_CTL_31
          desc: none
          resval: 0x0
          hwaccess: hro
          swaccess: ro
        }
        {
          bits: 34:32
          name: AR_PROT
          desc: none
          resval: 0x0
          hwaccess: hro
          swaccess: rw
        }
        {
          bits: 37:35
          name: AW_PROT
          desc: none
          resval: 0x0
          hwaccess: hro
          swaccess: rw
        }
        {
          bits: 38:38
          name: ARLEN_EN
          desc: none
          resval: 0x0
          hwaccess: hro
          swaccess: rw
        }
        {
          bits: 46:39
          name: ARLEN
          desc: none
          resval: 0x0
          hwaccess: hro
          swaccess: rw
        }
        {
          bits: 47:47
          name: AWLEN_EN
          desc: none
          resval: 0x0
          hwaccess: hro
          swaccess: rw
        }
        {
          bits: 55:48
          name: AWLEN
          desc: none
          resval: 0x0
          hwaccess: hro
          swaccess: rw
        }
        {
          bits: 56:56
          name: SRC_STAT_EN
          desc: none
          resval: 0x0
          hwaccess: hro
          swaccess: ro
        }
        {
          bits: 57:57
          name: DST_STAT_EN
          desc: none
          resval: 0x0
          hwaccess: hro
          swaccess: ro
        }
        {
          bits: 58:58
          name: IOC_BlkTfr
          desc: none
          resval: 0x0
          hwaccess: hro
          swaccess: rw
        }
        {
          bits: 61:59
          name: RSVD_DMAC_CHx_CTL_59to61
          desc: none
          resval: 0x0
          hwaccess: hro
          swaccess: ro
        }
        {
          bits: 62:62
          name: SHADOWREG_OR_LLI_LAST
          desc: none
          resval: 0x0
          hwaccess: hrw
          swaccess: rw
        }
        {
          bits: 63:63
          name: SHADOWREG_OR_LLI_VALID
          desc: none
          resval: 0x0
          hwaccess: hrw
          swaccess: rw
        }
      ]
      desc: none
      tags:
      [
        exc:CsrBitBashTest
      ]
    }
    {
      skipto: 0x120
    }
    {
      name: CH1_CFG
      fields:
      [
        {
          bits: 1:0
          name: SRC_MULTBLK_TYPE
          desc: none
          resval: 0x0
          hwaccess: hrw
          swaccess: rw
        }
        {
          bits: 3:2
          name: DST_MULTBLK_TYPE
          desc: none
          resval: 0x0
          hwaccess: hrw
          swaccess: rw
        }
        {
          bits: 16:4
          name: RSVD_DMAC_CHx_CFG_4to16
          desc: none
          resval: 0x0
          hwaccess: hrw
          swaccess: ro
        }
        {
          bits: 17:17
          name: LLI_AUTO_RESUME_REQ_EN
          desc: none
          resval: 0x0
          hwaccess: hrw
          swaccess: ro
        }
        {
          bits: 20:18
          name: RD_UID
          desc: none
          resval: 0x0
          hwaccess: hrw
          swaccess: rw
        }
        {
          bits: 24:21
          name: RSVD_DMAC_CHx_CFG_21to24
          desc: none
          resval: 0x0
          hwaccess: hrw
          swaccess: ro
        }
        {
          bits: 27:25
          name: WR_UID
          desc: none
          resval: 0x0
          hwaccess: hrw
          swaccess: rw
        }
        {
          bits: 31:28
          name: RSVD_DMAC_CHx_CFG_28to31
          desc: none
          resval: 0x0
          hwaccess: hrw
          swaccess: ro
        }
        {
          bits: 34:32
          name: TT_FC
          desc: none
          resval: 0x0
          hwaccess: hrw
          swaccess: ro
        }
        {
          bits: 35:35
          name: HS_SEL_SRC
          desc: none
          resval: 0x1
          hwaccess: hrw
          swaccess: rw
        }
        {
          bits: 36:36
          name: HS_SEL_DST
          desc: none
          resval: 0x1
          hwaccess: hrw
          swaccess: rw
        }
        {
          bits: 37:37
          name: SRC_HWHS_POL
          desc: none
          resval: 0x0
          hwaccess: hrw
          swaccess: ro
        }
        {
          bits: 38:38
          name: DST_HWHS_POL
          desc: none
          resval: 0x0
          hwaccess: hrw
          swaccess: ro
        }
        {
          bits: 39:39
          name: SRC_PER
          desc: none
          resval: 0x0
          hwaccess: hrw
          swaccess: ro
        }
        {
          bits: 42:40
          name: RSVD_DMAC_CHx_CFG_42_39
          desc: none
          resval: 0x0
          hwaccess: hrw
          swaccess: ro
        }
        {
          bits: 43:43
          name: RSVD_DMAC_CHx_CFG_43
          desc: none
          resval: 0x0
          hwaccess: hrw
          swaccess: ro
        }
        {
          bits: 44:44
          name: DST_PER
          desc: none
          resval: 0x0
          hwaccess: hrw
          swaccess: ro
        }
        {
          bits: 47:45
          name: RSVD_DMAC_CHx_CFG_47_44
          desc: none
          resval: 0x0
          hwaccess: hrw
          swaccess: ro
        }
        {
          bits: 48:48
          name: RSVD_DMAC_CHx_CFG_48
          desc: none
          resval: 0x0
          hwaccess: hrw
          swaccess: ro
        }
        {
          bits: 51:49
          name: CH_PRIOR
          desc: none
          resval: 0x1
          hwaccess: hrw
          swaccess: rw
        }
        {
          bits: 52:52
          name: LOCK_CH
          desc: none
          resval: 0x0
          hwaccess: hrw
          swaccess: ro
        }
        {
          bits: 54:53
          name: LOCK_CH_L
          desc: none
          resval: 0x0
          hwaccess: hrw
          swaccess: ro
        }
        {
          bits: 58:55
          name: SRC_OSR_LMT
          desc: none
          resval: 0x0
          hwaccess: hrw
          swaccess: rw
        }
        {
          bits: 62:59
          name: DST_OSR_LMT
          desc: none
          resval: 0x0
          hwaccess: hrw
          swaccess: rw
        }
        {
          bits: 63:63
          name: RSVD_DMAC_CHx_CFG_63
          desc: none
          resval: 0x0
          hwaccess: hrw
          swaccess: ro
        }
      ]
      desc: none
    }
    {
      skipto: 0x128
    }
    {
      name: CH1_LLP
      fields:
      [
        {
          bits: 0:0
          name: LMS
          desc: none
          resval: 0x0
          hwaccess: hrw
          swaccess: rw
        }
        {
          bits: 5:1
          name: RSVD_DMAC_CHx_LLP_1to5
          desc: none
          resval: 0x0
          hwaccess: hrw
          swaccess: ro
        }
        {
          bits: 63:6
          name: LOC
          desc: none
          resval: 0x0
          hwaccess: hrw
          swaccess: rw
        }
      ]
      desc: none
    }
    {
      skipto: 0x130
    }
    {
      name: CH1_STATUSREG
      fields:
      [
        {
          bits: 21:0
          name: CMPLTD_BLK_TFR_SIZE
          desc: none
          resval: 0x0
          hwaccess: hrw
          swaccess: ro
        }
        {
          bits: 31:22
          name: RSVD_DMAC_CHx_STATUSREG_22to31
          desc: none
          resval: 0x0
          hwaccess: hrw
          swaccess: ro
        }
        {
          bits: 46:32
          name: DATA_LEFT_IN_FIFO
          desc: none
          resval: 0x0
          hwaccess: hrw
          swaccess: ro
        }
        {
          bits: 63:47
          name: RSVD_DMAC_CHx_STATUSREG_47to63
          desc: none
          resval: 0x0
          hwaccess: hrw
          swaccess: ro
        }
      ]
      desc: none
      tags:
      [
        exc:CsrBitBashTest
      ]
    }
    {
      skipto: 0x138
    }
    {
      name: CH1_SWHSSRCREG
      fields:
      [
        {
          bits: 0:0
          name: SWHS_REQ_SRC
          desc: none
          resval: 0x0
          hwaccess: hrw
          swaccess: rw
        }
        {
          bits: 1:1
          name: SWHS_REQ_SRC_WE
          desc: none
          resval: 0x0
          hwaccess: hrw
          swaccess: wo
        }
        {
          bits: 2:2
          name: SWHS_SGLREQ_SRC
          desc: none
          resval: 0x0
          hwaccess: hrw
          swaccess: rw
        }
        {
          bits: 3:3
          name: SWHS_SGLREQ_SRC_WE
          desc: none
          resval: 0x0
          hwaccess: hrw
          swaccess: wo
        }
        {
          bits: 4:4
          name: SWHS_LST_SRC
          desc: none
          resval: 0x0
          hwaccess: hrw
          swaccess: rw
        }
        {
          bits: 5:5
          name: SWHS_LST_SRC_WE
          desc: none
          resval: 0x0
          hwaccess: hrw
          swaccess: wo
        }
        {
          bits: 63:6
          name: RSVD_DMAC_CHx_SWHSSRCREG_6to63
          desc: none
          resval: 0x0
          hwaccess: hrw
          swaccess: ro
        }
      ]
      desc: none
    }
    {
      skipto: 0x140
    }
    {
      name: CH1_SWHSDSTREG
      fields:
      [
        {
          bits: 0:0
          name: SWHS_REQ_DST
          desc: none
          resval: 0x0
          hwaccess: hrw
          swaccess: rw
        }
        {
          bits: 1:1
          name: SWHS_REQ_DST_WE
          desc: none
          resval: 0x0
          hwaccess: hrw
          swaccess: wo
        }
        {
          bits: 2:2
          name: SWHS_SGLREQ_DST
          desc: none
          resval: 0x0
          hwaccess: hrw
          swaccess: rw
        }
        {
          bits: 3:3
          name: SWHS_SGLREQ_DST_WE
          desc: none
          resval: 0x0
          hwaccess: hrw
          swaccess: wo
        }
        {
          bits: 4:4
          name: SWHS_LST_DST
          desc: none
          resval: 0x0
          hwaccess: hrw
          swaccess: rw
        }
        {
          bits: 5:5
          name: SWHS_LST_DST_WE
          desc: none
          resval: 0x0
          hwaccess: hrw
          swaccess: wo
        }
        {
          bits: 63:6
          name: RSVD_DMAC_CHx_SWHSDSTREG_6to63
          desc: none
          resval: 0x0
          hwaccess: hrw
          swaccess: ro
        }
      ]
      desc: none
    }
    {
      skipto: 0x148
    }
    {
      name: CH1_BLK_TFR_RESUMEREQREG
      fields:
      [
        {
          bits: 0:0
          name: BLK_TFR_RESUMEREQ
          desc: none
          resval: 0x0
          hwaccess: hro
          swaccess: wo
        }
        {
          bits: 63:1
          name: RSVD_DMAC_CHx_BLK_TFR_RESUMEREQREG_1to63
          desc: none
          resval: 0x0
          hwaccess: hro
          swaccess: wo
        }
      ]
      desc: none
      tags:
      [
        exc:CsrAllTests
      ]
    }
    {
      skipto: 0x150
    }
    {
      name: CH1_AXI_IDREG
      fields:
      [
        {
          bits: 3:0
          name: AXI_READ_ID_SUFFIX
          desc: none
          resval: 0x0
          hwaccess: hro
          swaccess: rw
        }
        {
          bits: 15:4
          name: RSVD_DMAC_CHx_AXI_IDREG_IDW_L2NCm1to31
          desc: none
          resval: 0x0
          hwaccess: hro
          swaccess: ro
        }
        {
          bits: 19:16
          name: AXI_WRITE_ID_SUFFIX
          desc: none
          resval: 0x0
          hwaccess: hro
          swaccess: rw
        }
        {
          bits: 31:20
          name: RSVD_DMAC_CHx_AXI_IDREG_IDW_L2NCm32to63
          desc: none
          resval: 0x0
          hwaccess: hro
          swaccess: ro
        }
        {
          bits: 63:32
          name: RSVD_DMAC_CHx_AXI_IDREG_32to63
          desc: none
          resval: 0x0
          hwaccess: hro
          swaccess: ro
        }
      ]
      desc: none
    }
    {
      skipto: 0x158
    }
    {
      name: CH1_AXI_QOSREG
      fields:
      [
        {
          bits: 3:0
          name: AXI_AWQOS
          desc: none
          resval: 0x0
          hwaccess: hro
          swaccess: ro
        }
        {
          bits: 7:4
          name: AXI_ARQOS
          desc: none
          resval: 0x0
          hwaccess: hro
          swaccess: ro
        }
        {
          bits: 63:8
          name: RSVD_DMAC_CHx_AXI_QOSREG_8to63
          desc: none
          resval: 0x0
          hwaccess: hro
          swaccess: ro
        }
      ]
      desc: none
      tags:
      [
        exc:CsrBitBashTest
      ]
    }
    {
      skipto: 0x180
    }
    {
      name: CH1_INTSTATUS_ENABLEREG
      fields:
      [
        {
          bits: 0:0
          name: Enable_BLOCK_TFR_DONE_IntStat
          desc: none
          resval: 0x1
          hwaccess: hro
          swaccess: rw
        }
        {
          bits: 1:1
          name: Enable_DMA_TFR_DONE_IntStat
          desc: none
          resval: 0x1
          hwaccess: hro
          swaccess: rw
        }
        {
          bits: 2:2
          name: RSVD_DMAC_CHx_INTSTATUS_ENABLEREG_2
          desc: none
          resval: 0x1
          hwaccess: hro
          swaccess: ro
        }
        {
          bits: 3:3
          name: Enable_SRC_TRANSCOMP_IntStat
          desc: none
          resval: 0x1
          hwaccess: hro
          swaccess: rw
        }
        {
          bits: 4:4
          name: Enable_DST_TRANSCOMP_IntStat
          desc: none
          resval: 0x1
          hwaccess: hro
          swaccess: rw
        }
        {
          bits: 5:5
          name: Enable_SRC_DEC_ERR_IntStat
          desc: none
          resval: 0x1
          hwaccess: hro
          swaccess: rw
        }
        {
          bits: 6:6
          name: Enable_DST_DEC_ERR_IntStat
          desc: none
          resval: 0x1
          hwaccess: hro
          swaccess: rw
        }
        {
          bits: 7:7
          name: Enable_SRC_SLV_ERR_IntStat
          desc: none
          resval: 0x1
          hwaccess: hro
          swaccess: rw
        }
        {
          bits: 8:8
          name: Enable_DST_SLV_ERR_IntStat
          desc: none
          resval: 0x1
          hwaccess: hro
          swaccess: rw
        }
        {
          bits: 9:9
          name: Enable_LLI_RD_DEC_ERR_IntStat
          desc: none
          resval: 0x1
          hwaccess: hro
          swaccess: rw
        }
        {
          bits: 10:10
          name: Enable_LLI_WR_DEC_ERR_IntStat
          desc: none
          resval: 0x1
          hwaccess: hro
          swaccess: rw
        }
        {
          bits: 11:11
          name: Enable_LLI_RD_SLV_ERR_IntStat
          desc: none
          resval: 0x1
          hwaccess: hro
          swaccess: rw
        }
        {
          bits: 12:12
          name: Enable_LLI_WR_SLV_ERR_IntStat
          desc: none
          resval: 0x1
          hwaccess: hro
          swaccess: rw
        }
        {
          bits: 13:13
          name: Enable_SHADOWREG_OR_LLI_INVALID_ERR_IntStat
          desc: none
          resval: 0x1
          hwaccess: hro
          swaccess: rw
        }
        {
          bits: 14:14
          name: Enable_SLVIF_MULTIBLKTYPE_ERR_IntStat
          desc: none
          resval: 0x1
          hwaccess: hro
          swaccess: rw
        }
        {
          bits: 15:15
          name: RSVD_DMAC_CHx_INTSTATUS_ENABLEREG_15
          desc: none
          resval: 0x1
          hwaccess: hro
          swaccess: ro
        }
        {
          bits: 16:16
          name: Enable_SLVIF_DEC_ERR_IntStat
          desc: none
          resval: 0x1
          hwaccess: hro
          swaccess: rw
        }
        {
          bits: 17:17
          name: Enable_SLVIF_WR2RO_ERR_IntStat
          desc: none
          resval: 0x1
          hwaccess: hro
          swaccess: rw
        }
        {
          bits: 18:18
          name: Enable_SLVIF_RD2RWO_ERR_IntStat
          desc: none
          resval: 0x1
          hwaccess: hro
          swaccess: rw
        }
        {
          bits: 19:19
          name: Enable_SLVIF_WRONCHEN_ERR_IntStat
          desc: none
          resval: 0x1
          hwaccess: hro
          swaccess: rw
        }
        {
          bits: 20:20
          name: Enable_SLVIF_SHADOWREG_WRON_VALID_ERR_IntStat
          desc: none
          resval: 0x1
          hwaccess: hro
          swaccess: rw
        }
        {
          bits: 21:21
          name: Enable_SLVIF_WRONHOLD_ERR_IntStat
          desc: none
          resval: 0x1
          hwaccess: hro
          swaccess: rw
        }
        {
          bits: 23:22
          name: RSVD_DMAC_CHx_INTSTATUS_ENABLEREG_22to23
          desc: none
          resval: 0x3
          hwaccess: hro
          swaccess: ro
        }
        {
          bits: 24:24
          name: Enable_SLVIF_ADDRPARITY_ERR_IntStat
          desc: none
          resval: 0x1
          hwaccess: hro
          swaccess: ro
        }
        {
          bits: 25:25
          name: Enable_SLVIF_WRPARITY_ERR_IntStat
          desc: none
          resval: 0x1
          hwaccess: hro
          swaccess: ro
        }
        {
          bits: 26:26
          name: RSVD_DMAC_CHx_INTSTATUS_ENABLEREG_26
          desc: none
          resval: 0x1
          hwaccess: hro
          swaccess: ro
        }
        {
          bits: 27:27
          name: Enable_CH_LOCK_CLEARED_IntStat
          desc: none
          resval: 0x1
          hwaccess: hro
          swaccess: rw
        }
        {
          bits: 28:28
          name: Enable_CH_SRC_SUSPENDED_IntStat
          desc: none
          resval: 0x1
          hwaccess: hro
          swaccess: rw
        }
        {
          bits: 29:29
          name: Enable_CH_SUSPENDED_IntStat
          desc: none
          resval: 0x1
          hwaccess: hro
          swaccess: rw
        }
        {
          bits: 30:30
          name: Enable_CH_DISABLED_IntStat
          desc: none
          resval: 0x1
          hwaccess: hro
          swaccess: rw
        }
        {
          bits: 31:31
          name: Enable_CH_ABORTED_IntStat
          desc: none
          resval: 0x1
          hwaccess: hro
          swaccess: rw
        }
        {
          bits: 32:32
          name: Enable_ECC_PROT_CHMem_CorrERR_IntStat
          desc: none
          resval: 0x1
          hwaccess: hro
          swaccess: ro
        }
        {
          bits: 33:33
          name: Enable_ECC_PROT_CHMem_UnCorrERR_IntStat
          desc: none
          resval: 0x1
          hwaccess: hro
          swaccess: ro
        }
        {
          bits: 34:34
          name: Enable_ECC_PROT_UIDMem_CorrERR_IntStat
          desc: none
          resval: 0x1
          hwaccess: hro
          swaccess: ro
        }
        {
          bits: 35:35
          name: Enable_ECC_PROT_UIDMem_UnCorrERR_IntStat
          desc: none
          resval: 0x1
          hwaccess: hro
          swaccess: ro
        }
        {
          bits: 63:36
          name: RSVD_DMAC_CHx_INTSTATUS_ENABLEREG_32to63
          desc: none
          resval: 0xfffffff
          hwaccess: hro
          swaccess: ro
        }
      ]
      desc: none
    }
    {
      skipto: 0x188
    }
    {
      name: CH1_INTSTATUS
      fields:
      [
        {
          bits: 0:0
          name: BLOCK_TFR_DONE_IntStat
          desc: none
          resval: 0x0
          hwaccess: hrw
          swaccess: ro
        }
        {
          bits: 1:1
          name: DMA_TFR_DONE_IntStat
          desc: none
          resval: 0x0
          hwaccess: hrw
          swaccess: ro
        }
        {
          bits: 2:2
          name: RSVD_DMAC_CHx_INTSTATUSREG_2
          desc: none
          resval: 0x0
          hwaccess: hrw
          swaccess: ro
        }
        {
          bits: 3:3
          name: SRC_TRANSCOMP_IntStat
          desc: none
          resval: 0x0
          hwaccess: hrw
          swaccess: ro
        }
        {
          bits: 4:4
          name: DST_TRANSCOMP_IntStat
          desc: none
          resval: 0x0
          hwaccess: hrw
          swaccess: ro
        }
        {
          bits: 5:5
          name: SRC_DEC_ERR_IntStat
          desc: none
          resval: 0x0
          hwaccess: hrw
          swaccess: ro
        }
        {
          bits: 6:6
          name: DST_DEC_ERR_IntStat
          desc: none
          resval: 0x0
          hwaccess: hrw
          swaccess: ro
        }
        {
          bits: 7:7
          name: SRC_SLV_ERR_IntStat
          desc: none
          resval: 0x0
          hwaccess: hrw
          swaccess: ro
        }
        {
          bits: 8:8
          name: DST_SLV_ERR_IntStat
          desc: none
          resval: 0x0
          hwaccess: hrw
          swaccess: ro
        }
        {
          bits: 9:9
          name: LLI_RD_DEC_ERR_IntStat
          desc: none
          resval: 0x0
          hwaccess: hrw
          swaccess: ro
        }
        {
          bits: 10:10
          name: LLI_WR_DEC_ERR_IntStat
          desc: none
          resval: 0x0
          hwaccess: hrw
          swaccess: ro
        }
        {
          bits: 11:11
          name: LLI_RD_SLV_ERR_IntStat
          desc: none
          resval: 0x0
          hwaccess: hrw
          swaccess: ro
        }
        {
          bits: 12:12
          name: LLI_WR_SLV_ERR_IntStat
          desc: none
          resval: 0x0
          hwaccess: hrw
          swaccess: ro
        }
        {
          bits: 13:13
          name: SHADOWREG_OR_LLI_INVALID_ERR_IntStat
          desc: none
          resval: 0x0
          hwaccess: hrw
          swaccess: ro
        }
        {
          bits: 14:14
          name: SLVIF_MULTIBLKTYPE_ERR_IntStat
          desc: none
          resval: 0x0
          hwaccess: hrw
          swaccess: ro
        }
        {
          bits: 15:15
          name: RSVD_DMAC_CHx_INTSTATUSREG_15
          desc: none
          resval: 0x0
          hwaccess: hrw
          swaccess: ro
        }
        {
          bits: 16:16
          name: SLVIF_DEC_ERR_IntStat
          desc: none
          resval: 0x0
          hwaccess: hrw
          swaccess: ro
        }
        {
          bits: 17:17
          name: SLVIF_WR2RO_ERR_IntStat
          desc: none
          resval: 0x0
          hwaccess: hrw
          swaccess: ro
        }
        {
          bits: 18:18
          name: SLVIF_RD2RWO_ERR_IntStat
          desc: none
          resval: 0x0
          hwaccess: hrw
          swaccess: ro
        }
        {
          bits: 19:19
          name: SLVIF_WRONCHEN_ERR_IntStat
          desc: none
          resval: 0x0
          hwaccess: hrw
          swaccess: ro
        }
        {
          bits: 20:20
          name: SLVIF_SHADOWREG_WRON_VALID_ERR_IntStat
          desc: none
          resval: 0x0
          hwaccess: hrw
          swaccess: ro
        }
        {
          bits: 21:21
          name: SLVIF_WRONHOLD_ERR_IntStat
          desc: none
          resval: 0x0
          hwaccess: hrw
          swaccess: ro
        }
        {
          bits: 23:22
          name: RSVD_DMAC_CHx_INTSTATUSREG_22to23
          desc: none
          resval: 0x0
          hwaccess: hrw
          swaccess: ro
        }
        {
          bits: 24:24
          name: SLVIF_ADDRPARITY_ERR_IntStat
          desc: none
          resval: 0x0
          hwaccess: hrw
          swaccess: ro
        }
        {
          bits: 25:25
          name: SLVIF_WRPARITY_ERR_IntStat
          desc: none
          resval: 0x0
          hwaccess: hrw
          swaccess: ro
        }
        {
          bits: 26:26
          name: RSVD_DMAC_CHx_INTSTATUSREG_26
          desc: none
          resval: 0x0
          hwaccess: hrw
          swaccess: ro
        }
        {
          bits: 27:27
          name: CH_LOCK_CLEARED_IntStat
          desc: none
          resval: 0x0
          hwaccess: hrw
          swaccess: ro
        }
        {
          bits: 28:28
          name: CH_SRC_SUSPENDED_IntStat
          desc: none
          resval: 0x0
          hwaccess: hrw
          swaccess: ro
        }
        {
          bits: 29:29
          name: CH_SUSPENDED_IntStat
          desc: none
          resval: 0x0
          hwaccess: hrw
          swaccess: ro
        }
        {
          bits: 30:30
          name: CH_DISABLED_IntStat
          desc: none
          resval: 0x0
          hwaccess: hrw
          swaccess: ro
        }
        {
          bits: 31:31
          name: CH_ABORTED_IntStat
          desc: none
          resval: 0x0
          hwaccess: hrw
          swaccess: ro
        }
        {
          bits: 32:32
          name: ECC_PROT_CHMem_CorrERR_IntStat
          desc: none
          resval: 0x0
          hwaccess: hrw
          swaccess: ro
        }
        {
          bits: 33:33
          name: ECC_PROT_CHMem_UnCorrERR_IntStat
          desc: none
          resval: 0x0
          hwaccess: hrw
          swaccess: ro
        }
        {
          bits: 34:34
          name: ECC_PROT_UIDMem_CorrERR_IntStat
          desc: none
          resval: 0x0
          hwaccess: hrw
          swaccess: ro
        }
        {
          bits: 35:35
          name: ECC_PROT_UIDMem_UnCorrERR_IntStat
          desc: none
          resval: 0x0
          hwaccess: hrw
          swaccess: ro
        }
        {
          bits: 63:36
          name: RSVD_DMAC_CHx_INTSTATUSREG_36to63
          desc: none
          resval: 0x0
          hwaccess: hrw
          swaccess: ro
        }
      ]
      desc: none
      tags:
      [
        exc:CsrBitBashTest
      ]
    }
    {
      skipto: 0x190
    }
    {
      name: CH1_INTSIGNAL_ENABLEREG
      fields:
      [
        {
          bits: 0:0
          name: Enable_BLOCK_TFR_DONE_IntSignal
          desc: none
          resval: 0x1
          hwaccess: hro
          swaccess: rw
        }
        {
          bits: 1:1
          name: Enable_DMA_TFR_DONE_IntSignal
          desc: none
          resval: 0x1
          hwaccess: hro
          swaccess: rw
        }
        {
          bits: 2:2
          name: RSVD_DMAC_CHx_INTSTATUS_ENABLEREG_2
          desc: none
          resval: 0x1
          hwaccess: hro
          swaccess: ro
        }
        {
          bits: 3:3
          name: Enable_SRC_TRANSCOMP_IntSignal
          desc: none
          resval: 0x1
          hwaccess: hro
          swaccess: rw
        }
        {
          bits: 4:4
          name: Enable_DST_TRANSCOMP_IntSignal
          desc: none
          resval: 0x1
          hwaccess: hro
          swaccess: rw
        }
        {
          bits: 5:5
          name: Enable_SRC_DEC_ERR_IntSignal
          desc: none
          resval: 0x1
          hwaccess: hro
          swaccess: rw
        }
        {
          bits: 6:6
          name: Enable_DST_DEC_ERR_IntSignal
          desc: none
          resval: 0x1
          hwaccess: hro
          swaccess: rw
        }
        {
          bits: 7:7
          name: Enable_SRC_SLV_ERR_IntSignal
          desc: none
          resval: 0x1
          hwaccess: hro
          swaccess: rw
        }
        {
          bits: 8:8
          name: Enable_DST_SLV_ERR_IntSignal
          desc: none
          resval: 0x1
          hwaccess: hro
          swaccess: rw
        }
        {
          bits: 9:9
          name: Enable_LLI_RD_DEC_ERR_IntSignal
          desc: none
          resval: 0x1
          hwaccess: hro
          swaccess: rw
        }
        {
          bits: 10:10
          name: Enable_LLI_WR_DEC_ERR_IntSignal
          desc: none
          resval: 0x1
          hwaccess: hro
          swaccess: rw
        }
        {
          bits: 11:11
          name: Enable_LLI_RD_SLV_ERR_IntSignal
          desc: none
          resval: 0x1
          hwaccess: hro
          swaccess: rw
        }
        {
          bits: 12:12
          name: Enable_LLI_WR_SLV_ERR_IntSignal
          desc: none
          resval: 0x1
          hwaccess: hro
          swaccess: rw
        }
        {
          bits: 13:13
          name: Enable_SHADOWREG_OR_LLI_INVALID_ERR_IntSignal
          desc: none
          resval: 0x1
          hwaccess: hro
          swaccess: rw
        }
        {
          bits: 14:14
          name: Enable_SLVIF_MULTIBLKTYPE_ERR_IntSignal
          desc: none
          resval: 0x1
          hwaccess: hro
          swaccess: rw
        }
        {
          bits: 15:15
          name: RSVD_DMAC_CHx_INTSTATUS_ENABLEREG_15
          desc: none
          resval: 0x1
          hwaccess: hro
          swaccess: ro
        }
        {
          bits: 16:16
          name: Enable_SLVIF_DEC_ERR_IntSignal
          desc: none
          resval: 0x1
          hwaccess: hro
          swaccess: rw
        }
        {
          bits: 17:17
          name: Enable_SLVIF_WR2RO_ERR_IntSignal
          desc: none
          resval: 0x1
          hwaccess: hro
          swaccess: rw
        }
        {
          bits: 18:18
          name: Enable_SLVIF_RD2RWO_ERR_IntSignal
          desc: none
          resval: 0x1
          hwaccess: hro
          swaccess: rw
        }
        {
          bits: 19:19
          name: Enable_SLVIF_WRONCHEN_ERR_IntSignal
          desc: none
          resval: 0x1
          hwaccess: hro
          swaccess: rw
        }
        {
          bits: 20:20
          name: Enable_SLVIF_SHADOWREG_WRON_VALID_ERR_IntSignal
          desc: none
          resval: 0x1
          hwaccess: hro
          swaccess: rw
        }
        {
          bits: 21:21
          name: Enable_SLVIF_WRONHOLD_ERR_IntSignal
          desc: none
          resval: 0x1
          hwaccess: hro
          swaccess: rw
        }
        {
          bits: 23:22
          name: RSVD_DMAC_CHx_INTSIGNAL_ENABLEREG_22to23
          desc: none
          resval: 0x3
          hwaccess: hro
          swaccess: ro
        }
        {
          bits: 24:24
          name: Enable_SLVIF_ADDRPARITY_ERR_IntSignal
          desc: none
          resval: 0x1
          hwaccess: hro
          swaccess: ro
        }
        {
          bits: 25:25
          name: Enable_SLVIF_WRPARITY_ERR_IntSignal
          desc: none
          resval: 0x1
          hwaccess: hro
          swaccess: ro
        }
        {
          bits: 26:26
          name: RSVD_DMAC_CHx_INTSIGNAL_ENABLEREG_26
          desc: none
          resval: 0x1
          hwaccess: hro
          swaccess: ro
        }
        {
          bits: 27:27
          name: Enable_CH_LOCK_CLEARED_IntSignal
          desc: none
          resval: 0x1
          hwaccess: hro
          swaccess: rw
        }
        {
          bits: 28:28
          name: Enable_CH_SRC_SUSPENDED_IntSignal
          desc: none
          resval: 0x1
          hwaccess: hro
          swaccess: rw
        }
        {
          bits: 29:29
          name: Enable_CH_SUSPENDED_IntSignal
          desc: none
          resval: 0x1
          hwaccess: hro
          swaccess: rw
        }
        {
          bits: 30:30
          name: Enable_CH_DISABLED_IntSignal
          desc: none
          resval: 0x1
          hwaccess: hro
          swaccess: rw
        }
        {
          bits: 31:31
          name: Enable_CH_ABORTED_IntSignal
          desc: none
          resval: 0x1
          hwaccess: hro
          swaccess: rw
        }
        {
          bits: 32:32
          name: Enable_ECC_PROT_CHMem_CorrERR_IntSignal
          desc: none
          resval: 0x1
          hwaccess: hro
          swaccess: ro
        }
        {
          bits: 33:33
          name: Enable_ECC_PROT_CHMem_UnCorrERR_IntSignal
          desc: none
          resval: 0x1
          hwaccess: hro
          swaccess: ro
        }
        {
          bits: 34:34
          name: Enable_ECC_PROT_UIDMem_CorrERR_IntSignal
          desc: none
          resval: 0x1
          hwaccess: hro
          swaccess: ro
        }
        {
          bits: 35:35
          name: Enable_ECC_PROT_UIDMem_UnCorrERR_IntSignal
          desc: none
          resval: 0x1
          hwaccess: hro
          swaccess: ro
        }
        {
          bits: 63:36
          name: RSVD_DMAC_CHx_INTSIGNAL_ENABLEREG_36to63
          desc: none
          resval: 0xfffffff
          hwaccess: hro
          swaccess: ro
        }
      ]
      desc: none
    }
    {
      skipto: 0x198
    }
    {
      name: CH1_INTCLEARREG
      fields:
      [
        {
          bits: 0:0
          name: Clear_BLOCK_TFR_DONE_IntStat
          desc: none
          resval: 0x0
          hwaccess: hro
          swaccess: wo
        }
        {
          bits: 1:1
          name: Clear_DMA_TFR_DONE_IntStat
          desc: none
          resval: 0x0
          hwaccess: hro
          swaccess: wo
        }
        {
          bits: 2:2
          name: RSVD_DMAC_CHx_INTCLEARREG_2
          desc: none
          resval: 0x0
          hwaccess: hro
          swaccess: wo
        }
        {
          bits: 3:3
          name: Clear_SRC_TRANSCOMP_IntStat
          desc: none
          resval: 0x0
          hwaccess: hro
          swaccess: wo
        }
        {
          bits: 4:4
          name: Clear_DST_TRANSCOMP_IntStat
          desc: none
          resval: 0x0
          hwaccess: hro
          swaccess: wo
        }
        {
          bits: 5:5
          name: Clear_SRC_DEC_ERR_IntStat
          desc: none
          resval: 0x0
          hwaccess: hro
          swaccess: wo
        }
        {
          bits: 6:6
          name: Clear_DST_DEC_ERR_IntStat
          desc: none
          resval: 0x0
          hwaccess: hro
          swaccess: wo
        }
        {
          bits: 7:7
          name: Clear_SRC_SLV_ERR_IntStat
          desc: none
          resval: 0x0
          hwaccess: hro
          swaccess: wo
        }
        {
          bits: 8:8
          name: Clear_DST_SLV_ERR_IntStat
          desc: none
          resval: 0x0
          hwaccess: hro
          swaccess: wo
        }
        {
          bits: 9:9
          name: Clear_LLI_RD_DEC_ERR_IntStat
          desc: none
          resval: 0x0
          hwaccess: hro
          swaccess: wo
        }
        {
          bits: 10:10
          name: Clear_LLI_WR_DEC_ERR_IntStat
          desc: none
          resval: 0x0
          hwaccess: hro
          swaccess: wo
        }
        {
          bits: 11:11
          name: Clear_LLI_RD_SLV_ERR_IntStat
          desc: none
          resval: 0x0
          hwaccess: hro
          swaccess: wo
        }
        {
          bits: 12:12
          name: Clear_LLI_WR_SLV_ERR_IntStat
          desc: none
          resval: 0x0
          hwaccess: hro
          swaccess: wo
        }
        {
          bits: 13:13
          name: Clear_SHADOWREG_OR_LLI_INVALID_ERR_IntStat
          desc: none
          resval: 0x0
          hwaccess: hro
          swaccess: wo
        }
        {
          bits: 14:14
          name: Clear_SLVIF_MULTIBLKTYPE_ERR_IntStat
          desc: none
          resval: 0x0
          hwaccess: hro
          swaccess: wo
        }
        {
          bits: 15:15
          name: RSVD_DMAC_CHx_INTCLEARREG_15
          desc: none
          resval: 0x0
          hwaccess: hro
          swaccess: wo
        }
        {
          bits: 16:16
          name: Clear_SLVIF_DEC_ERR_IntStat
          desc: none
          resval: 0x0
          hwaccess: hro
          swaccess: wo
        }
        {
          bits: 17:17
          name: Clear_SLVIF_WR2RO_ERR_IntStat
          desc: none
          resval: 0x0
          hwaccess: hro
          swaccess: wo
        }
        {
          bits: 18:18
          name: Clear_SLVIF_RD2RWO_ERR_IntStat
          desc: none
          resval: 0x0
          hwaccess: hro
          swaccess: wo
        }
        {
          bits: 19:19
          name: Clear_SLVIF_WRONCHEN_ERR_IntStat
          desc: none
          resval: 0x0
          hwaccess: hro
          swaccess: wo
        }
        {
          bits: 20:20
          name: Clear_SLVIF_SHADOWREG_WRON_VALID_ERR_IntStat
          desc: none
          resval: 0x0
          hwaccess: hro
          swaccess: wo
        }
        {
          bits: 21:21
          name: Clear_SLVIF_WRONHOLD_ERR_IntStat
          desc: none
          resval: 0x0
          hwaccess: hro
          swaccess: wo
        }
        {
          bits: 23:22
          name: RSVD_DMAC_CHx_INTCLEARREG_22to23
          desc: none
          resval: 0x0
          hwaccess: hro
          swaccess: wo
        }
        {
          bits: 24:24
          name: Clear_SLVIF_ADDRPARITY_ERR_IntStat
          desc: none
          resval: 0x0
          hwaccess: hro
          swaccess: wo
        }
        {
          bits: 25:25
          name: Clear_SLVIF_WRPARITY_ERR_IntStat
          desc: none
          resval: 0x0
          hwaccess: hro
          swaccess: wo
        }
        {
          bits: 26:26
          name: RSVD_DMAC_CHx_INTCLEARREG_26
          desc: none
          resval: 0x0
          hwaccess: hro
          swaccess: wo
        }
        {
          bits: 27:27
          name: Clear_CH_LOCK_CLEARED_IntStat
          desc: none
          resval: 0x0
          hwaccess: hro
          swaccess: wo
        }
        {
          bits: 28:28
          name: Clear_CH_SRC_SUSPENDED_IntStat
          desc: none
          resval: 0x0
          hwaccess: hro
          swaccess: wo
        }
        {
          bits: 29:29
          name: Clear_CH_SUSPENDED_IntStat
          desc: none
          resval: 0x0
          hwaccess: hro
          swaccess: wo
        }
        {
          bits: 30:30
          name: Clear_CH_DISABLED_IntStat
          desc: none
          resval: 0x0
          hwaccess: hro
          swaccess: wo
        }
        {
          bits: 31:31
          name: Clear_CH_ABORTED_IntStat
          desc: none
          resval: 0x0
          hwaccess: hro
          swaccess: wo
        }
        {
          bits: 32:32
          name: Clear_ECC_PROT_CHMem_CorrERR_IntStat
          desc: none
          resval: 0x0
          hwaccess: hro
          swaccess: wo
        }
        {
          bits: 33:33
          name: Clear_ECC_PROT_CHMem_UnCorrERR_IntStat
          desc: none
          resval: 0x0
          hwaccess: hro
          swaccess: wo
        }
        {
          bits: 34:34
          name: Clear_ECC_PROT_UIDMem_CorrERR_IntStat
          desc: none
          resval: 0x0
          hwaccess: hro
          swaccess: wo
        }
        {
          bits: 35:35
          name: Clear_ECC_PROT_UIDMem_UnCorrERR_IntStat
          desc: none
          resval: 0x0
          hwaccess: hro
          swaccess: wo
        }
        {
          bits: 63:36
          name: RSVD_DMAC_CHx_INTCLEARREG_36to63
          desc: none
          resval: 0x0
          hwaccess: hro
          swaccess: wo
        }
      ]
      desc: none
      tags:
      [
        exc:CsrAllTests
      ]
    }
    {
      skipto: 0x1a0
    }
    {
      name: CH1_CFG_EXTD
      fields:
      [
        {
          bits: 2:0
          name: LLI_AXPROT
          desc: none
          resval: 0x0
          hwaccess: hro
          swaccess: rw
        }
        {
          bits: 6:3
          name: LLI_AXCACHE
          desc: none
          resval: 0x0
          hwaccess: hro
          swaccess: rw
        }
        {
          bits: 63:7
          name: RSVD_DMAC_CHx_CFG_EXTD_7to63
          desc: none
          resval: 0x0
          hwaccess: hro
          swaccess: ro
        }
      ]
      desc: none
    }
    {
      skipto: 0x200
    }
    {
      name: CH2_SAR
      fields:
      [
        {
          bits: 63:0
          name: SAR
          desc: none
          resval: 0x0
          hwaccess: hrw
          swaccess: rw
        }
      ]
      desc: none
    }
    {
      skipto: 0x208
    }
    {
      name: CH2_DAR
      fields:
      [
        {
          bits: 63:0
          name: DAR
          desc: none
          resval: 0x0
          hwaccess: hrw
          swaccess: rw
        }
      ]
      desc: none
    }
    {
      skipto: 0x210
    }
    {
      name: CH2_BLOCK_TS
      fields:
      [
        {
          bits: 21:0
          name: BLOCK_TS
          desc: none
          resval: 0x0
          hwaccess: hrw
          swaccess: rw
        }
        {
          bits: 63:22
          name: RSVD_DMAC_CHx_BLOCK_TSREG_63to22
          desc: none
          resval: 0x0
          hwaccess: hrw
          swaccess: ro
        }
      ]
      desc: none
    }
    {
      skipto: 0x218
    }
    {
      name: CH2_CTL
      fields:
      [
        {
          bits: 0:0
          name: SMS
          desc: none
          resval: 0x0
          hwaccess: hro
          swaccess: rw
        }
        {
          bits: 1:1
          name: RSVD_DMAC_CHx_CTL_1
          desc: none
          resval: 0x0
          hwaccess: hro
          swaccess: ro
        }
        {
          bits: 2:2
          name: DMS
          desc: none
          resval: 0x0
          hwaccess: hro
          swaccess: rw
        }
        {
          bits: 3:3
          name: RSVD_DMAC_CHx_CTL_3
          desc: none
          resval: 0x0
          hwaccess: hro
          swaccess: ro
        }
        {
          bits: 4:4
          name: SINC
          desc: none
          resval: 0x0
          hwaccess: hro
          swaccess: rw
        }
        {
          bits: 5:5
          name: RSVD_DMAC_CHx_CTL_5
          desc: none
          resval: 0x0
          hwaccess: hro
          swaccess: ro
        }
        {
          bits: 6:6
          name: DINC
          desc: none
          resval: 0x0
          hwaccess: hro
          swaccess: rw
        }
        {
          bits: 7:7
          name: CRC_EN
          desc: none
          resval: 0x0
          hwaccess: hro
          swaccess: ro
        }
        {
          bits: 10:8
          name: SRC_TR_WIDTH
          desc: none
          resval: 0x2
          hwaccess: hro
          swaccess: rw
        }
        {
          bits: 13:11
          name: DST_TR_WIDTH
          desc: none
          resval: 0x2
          hwaccess: hro
          swaccess: rw
        }
        {
          bits: 17:14
          name: SRC_MSIZE
          desc: none
          resval: 0x0
          hwaccess: hro
          swaccess: rw
        }
        {
          bits: 21:18
          name: DST_MSIZE
          desc: none
          resval: 0x0
          hwaccess: hro
          swaccess: rw
        }
        {
          bits: 25:22
          name: AR_CACHE
          desc: none
          resval: 0x0
          hwaccess: hro
          swaccess: rw
        }
        {
          bits: 29:26
          name: AW_CACHE
          desc: none
          resval: 0x0
          hwaccess: hro
          swaccess: rw
        }
        {
          bits: 30:30
          name: NonPosted_LastWrite_En
          desc: none
          resval: 0x0
          hwaccess: hro
          swaccess: rw
        }
        {
          bits: 31:31
          name: RSVD_DMAC_CHx_CTL_31
          desc: none
          resval: 0x0
          hwaccess: hro
          swaccess: ro
        }
        {
          bits: 34:32
          name: AR_PROT
          desc: none
          resval: 0x0
          hwaccess: hro
          swaccess: rw
        }
        {
          bits: 37:35
          name: AW_PROT
          desc: none
          resval: 0x0
          hwaccess: hro
          swaccess: rw
        }
        {
          bits: 38:38
          name: ARLEN_EN
          desc: none
          resval: 0x0
          hwaccess: hro
          swaccess: rw
        }
        {
          bits: 46:39
          name: ARLEN
          desc: none
          resval: 0x0
          hwaccess: hro
          swaccess: rw
        }
        {
          bits: 47:47
          name: AWLEN_EN
          desc: none
          resval: 0x0
          hwaccess: hro
          swaccess: rw
        }
        {
          bits: 55:48
          name: AWLEN
          desc: none
          resval: 0x0
          hwaccess: hro
          swaccess: rw
        }
        {
          bits: 56:56
          name: SRC_STAT_EN
          desc: none
          resval: 0x0
          hwaccess: hro
          swaccess: ro
        }
        {
          bits: 57:57
          name: DST_STAT_EN
          desc: none
          resval: 0x0
          hwaccess: hro
          swaccess: ro
        }
        {
          bits: 58:58
          name: IOC_BlkTfr
          desc: none
          resval: 0x0
          hwaccess: hro
          swaccess: rw
        }
        {
          bits: 61:59
          name: RSVD_DMAC_CHx_CTL_59to61
          desc: none
          resval: 0x0
          hwaccess: hro
          swaccess: ro
        }
        {
          bits: 62:62
          name: SHADOWREG_OR_LLI_LAST
          desc: none
          resval: 0x0
          hwaccess: hrw
          swaccess: rw
        }
        {
          bits: 63:63
          name: SHADOWREG_OR_LLI_VALID
          desc: none
          resval: 0x0
          hwaccess: hrw
          swaccess: rw
        }
      ]
      desc: none
      tags:
      [
        exc:CsrBitBashTest
      ]
    }
    {
      skipto: 0x220
    }
    {
      name: CH2_CFG
      fields:
      [
        {
          bits: 1:0
          name: SRC_MULTBLK_TYPE
          desc: none
          resval: 0x0
          hwaccess: hrw
          swaccess: rw
        }
        {
          bits: 3:2
          name: DST_MULTBLK_TYPE
          desc: none
          resval: 0x0
          hwaccess: hrw
          swaccess: rw
        }
        {
          bits: 16:4
          name: RSVD_DMAC_CHx_CFG_4to16
          desc: none
          resval: 0x0
          hwaccess: hrw
          swaccess: ro
        }
        {
          bits: 17:17
          name: LLI_AUTO_RESUME_REQ_EN
          desc: none
          resval: 0x0
          hwaccess: hrw
          swaccess: ro
        }
        {
          bits: 20:18
          name: RD_UID
          desc: none
          resval: 0x0
          hwaccess: hrw
          swaccess: rw
        }
        {
          bits: 24:21
          name: RSVD_DMAC_CHx_CFG_21to24
          desc: none
          resval: 0x0
          hwaccess: hrw
          swaccess: ro
        }
        {
          bits: 27:25
          name: WR_UID
          desc: none
          resval: 0x0
          hwaccess: hrw
          swaccess: rw
        }
        {
          bits: 31:28
          name: RSVD_DMAC_CHx_CFG_28to31
          desc: none
          resval: 0x0
          hwaccess: hrw
          swaccess: ro
        }
        {
          bits: 34:32
          name: TT_FC
          desc: none
          resval: 0x0
          hwaccess: hrw
          swaccess: ro
        }
        {
          bits: 35:35
          name: HS_SEL_SRC
          desc: none
          resval: 0x1
          hwaccess: hrw
          swaccess: rw
        }
        {
          bits: 36:36
          name: HS_SEL_DST
          desc: none
          resval: 0x1
          hwaccess: hrw
          swaccess: rw
        }
        {
          bits: 37:37
          name: SRC_HWHS_POL
          desc: none
          resval: 0x0
          hwaccess: hrw
          swaccess: ro
        }
        {
          bits: 38:38
          name: DST_HWHS_POL
          desc: none
          resval: 0x0
          hwaccess: hrw
          swaccess: ro
        }
        {
          bits: 39:39
          name: SRC_PER
          desc: none
          resval: 0x0
          hwaccess: hrw
          swaccess: ro
        }
        {
          bits: 42:40
          name: RSVD_DMAC_CHx_CFG_42_39
          desc: none
          resval: 0x0
          hwaccess: hrw
          swaccess: ro
        }
        {
          bits: 43:43
          name: RSVD_DMAC_CHx_CFG_43
          desc: none
          resval: 0x0
          hwaccess: hrw
          swaccess: ro
        }
        {
          bits: 44:44
          name: DST_PER
          desc: none
          resval: 0x0
          hwaccess: hrw
          swaccess: ro
        }
        {
          bits: 47:45
          name: RSVD_DMAC_CHx_CFG_47_44
          desc: none
          resval: 0x0
          hwaccess: hrw
          swaccess: ro
        }
        {
          bits: 48:48
          name: RSVD_DMAC_CHx_CFG_48
          desc: none
          resval: 0x0
          hwaccess: hrw
          swaccess: ro
        }
        {
          bits: 51:49
          name: CH_PRIOR
          desc: none
          resval: 0x0
          hwaccess: hrw
          swaccess: rw
        }
        {
          bits: 52:52
          name: LOCK_CH
          desc: none
          resval: 0x0
          hwaccess: hrw
          swaccess: ro
        }
        {
          bits: 54:53
          name: LOCK_CH_L
          desc: none
          resval: 0x0
          hwaccess: hrw
          swaccess: ro
        }
        {
          bits: 58:55
          name: SRC_OSR_LMT
          desc: none
          resval: 0x0
          hwaccess: hrw
          swaccess: rw
        }
        {
          bits: 62:59
          name: DST_OSR_LMT
          desc: none
          resval: 0x0
          hwaccess: hrw
          swaccess: rw
        }
        {
          bits: 63:63
          name: RSVD_DMAC_CHx_CFG_63
          desc: none
          resval: 0x0
          hwaccess: hrw
          swaccess: ro
        }
      ]
      desc: none
    }
    {
      skipto: 0x228
    }
    {
      name: CH2_LLP
      fields:
      [
        {
          bits: 0:0
          name: LMS
          desc: none
          resval: 0x0
          hwaccess: hrw
          swaccess: rw
        }
        {
          bits: 5:1
          name: RSVD_DMAC_CHx_LLP_1to5
          desc: none
          resval: 0x0
          hwaccess: hrw
          swaccess: ro
        }
        {
          bits: 63:6
          name: LOC
          desc: none
          resval: 0x0
          hwaccess: hrw
          swaccess: rw
        }
      ]
      desc: none
    }
    {
      skipto: 0x230
    }
    {
      name: CH2_STATUSREG
      fields:
      [
        {
          bits: 21:0
          name: CMPLTD_BLK_TFR_SIZE
          desc: none
          resval: 0x0
          hwaccess: hrw
          swaccess: ro
        }
        {
          bits: 31:22
          name: RSVD_DMAC_CHx_STATUSREG_22to31
          desc: none
          resval: 0x0
          hwaccess: hrw
          swaccess: ro
        }
        {
          bits: 46:32
          name: DATA_LEFT_IN_FIFO
          desc: none
          resval: 0x0
          hwaccess: hrw
          swaccess: ro
        }
        {
          bits: 63:47
          name: RSVD_DMAC_CHx_STATUSREG_47to63
          desc: none
          resval: 0x0
          hwaccess: hrw
          swaccess: ro
        }
      ]
      desc: none
      tags:
      [
        exc:CsrBitBashTest
      ]
    }
    {
      skipto: 0x238
    }
    {
      name: CH2_SWHSSRCREG
      fields:
      [
        {
          bits: 0:0
          name: SWHS_REQ_SRC
          desc: none
          resval: 0x0
          hwaccess: hrw
          swaccess: rw
        }
        {
          bits: 1:1
          name: SWHS_REQ_SRC_WE
          desc: none
          resval: 0x0
          hwaccess: hrw
          swaccess: wo
        }
        {
          bits: 2:2
          name: SWHS_SGLREQ_SRC
          desc: none
          resval: 0x0
          hwaccess: hrw
          swaccess: rw
        }
        {
          bits: 3:3
          name: SWHS_SGLREQ_SRC_WE
          desc: none
          resval: 0x0
          hwaccess: hrw
          swaccess: wo
        }
        {
          bits: 4:4
          name: SWHS_LST_SRC
          desc: none
          resval: 0x0
          hwaccess: hrw
          swaccess: rw
        }
        {
          bits: 5:5
          name: SWHS_LST_SRC_WE
          desc: none
          resval: 0x0
          hwaccess: hrw
          swaccess: wo
        }
        {
          bits: 63:6
          name: RSVD_DMAC_CHx_SWHSSRCREG_6to63
          desc: none
          resval: 0x0
          hwaccess: hrw
          swaccess: ro
        }
      ]
      desc: none
    }
    {
      skipto: 0x240
    }
    {
      name: CH2_SWHSDSTREG
      fields:
      [
        {
          bits: 0:0
          name: SWHS_REQ_DST
          desc: none
          resval: 0x0
          hwaccess: hrw
          swaccess: rw
        }
        {
          bits: 1:1
          name: SWHS_REQ_DST_WE
          desc: none
          resval: 0x0
          hwaccess: hrw
          swaccess: wo
        }
        {
          bits: 2:2
          name: SWHS_SGLREQ_DST
          desc: none
          resval: 0x0
          hwaccess: hrw
          swaccess: rw
        }
        {
          bits: 3:3
          name: SWHS_SGLREQ_DST_WE
          desc: none
          resval: 0x0
          hwaccess: hrw
          swaccess: wo
        }
        {
          bits: 4:4
          name: SWHS_LST_DST
          desc: none
          resval: 0x0
          hwaccess: hrw
          swaccess: rw
        }
        {
          bits: 5:5
          name: SWHS_LST_DST_WE
          desc: none
          resval: 0x0
          hwaccess: hrw
          swaccess: wo
        }
        {
          bits: 63:6
          name: RSVD_DMAC_CHx_SWHSDSTREG_6to63
          desc: none
          resval: 0x0
          hwaccess: hrw
          swaccess: ro
        }
      ]
      desc: none
    }
    {
      skipto: 0x248
    }
    {
      name: CH2_BLK_TFR_RESUMEREQREG
      fields:
      [
        {
          bits: 0:0
          name: BLK_TFR_RESUMEREQ
          desc: none
          resval: 0x0
          hwaccess: hro
          swaccess: wo
        }
        {
          bits: 63:1
          name: RSVD_DMAC_CHx_BLK_TFR_RESUMEREQREG_1to63
          desc: none
          resval: 0x0
          hwaccess: hro
          swaccess: wo
        }
      ]
      desc: none
      tags:
      [
        exc:CsrAllTests
      ]
    }
    {
      skipto: 0x250
    }
    {
      name: CH2_AXI_IDREG
      fields:
      [
        {
          bits: 3:0
          name: AXI_READ_ID_SUFFIX
          desc: none
          resval: 0x0
          hwaccess: hro
          swaccess: rw
        }
        {
          bits: 15:4
          name: RSVD_DMAC_CHx_AXI_IDREG_IDW_L2NCm1to31
          desc: none
          resval: 0x0
          hwaccess: hro
          swaccess: ro
        }
        {
          bits: 19:16
          name: AXI_WRITE_ID_SUFFIX
          desc: none
          resval: 0x0
          hwaccess: hro
          swaccess: rw
        }
        {
          bits: 31:20
          name: RSVD_DMAC_CHx_AXI_IDREG_IDW_L2NCm32to63
          desc: none
          resval: 0x0
          hwaccess: hro
          swaccess: ro
        }
        {
          bits: 63:32
          name: RSVD_DMAC_CHx_AXI_IDREG_32to63
          desc: none
          resval: 0x0
          hwaccess: hro
          swaccess: ro
        }
      ]
      desc: none
    }
    {
      skipto: 0x258
    }
    {
      name: CH2_AXI_QOSREG
      fields:
      [
        {
          bits: 3:0
          name: AXI_AWQOS
          desc: none
          resval: 0x0
          hwaccess: hro
          swaccess: ro
        }
        {
          bits: 7:4
          name: AXI_ARQOS
          desc: none
          resval: 0x0
          hwaccess: hro
          swaccess: ro
        }
        {
          bits: 63:8
          name: RSVD_DMAC_CHx_AXI_QOSREG_8to63
          desc: none
          resval: 0x0
          hwaccess: hro
          swaccess: ro
        }
      ]
      desc: none
      tags:
      [
        exc:CsrBitBashTest
      ]
    }
    {
      skipto: 0x280
    }
    {
      name: CH2_INTSTATUS_ENABLEREG
      fields:
      [
        {
          bits: 0:0
          name: Enable_BLOCK_TFR_DONE_IntStat
          desc: none
          resval: 0x1
          hwaccess: hro
          swaccess: rw
        }
        {
          bits: 1:1
          name: Enable_DMA_TFR_DONE_IntStat
          desc: none
          resval: 0x1
          hwaccess: hro
          swaccess: rw
        }
        {
          bits: 2:2
          name: RSVD_DMAC_CHx_INTSTATUS_ENABLEREG_2
          desc: none
          resval: 0x1
          hwaccess: hro
          swaccess: ro
        }
        {
          bits: 3:3
          name: Enable_SRC_TRANSCOMP_IntStat
          desc: none
          resval: 0x1
          hwaccess: hro
          swaccess: rw
        }
        {
          bits: 4:4
          name: Enable_DST_TRANSCOMP_IntStat
          desc: none
          resval: 0x1
          hwaccess: hro
          swaccess: rw
        }
        {
          bits: 5:5
          name: Enable_SRC_DEC_ERR_IntStat
          desc: none
          resval: 0x1
          hwaccess: hro
          swaccess: rw
        }
        {
          bits: 6:6
          name: Enable_DST_DEC_ERR_IntStat
          desc: none
          resval: 0x1
          hwaccess: hro
          swaccess: rw
        }
        {
          bits: 7:7
          name: Enable_SRC_SLV_ERR_IntStat
          desc: none
          resval: 0x1
          hwaccess: hro
          swaccess: rw
        }
        {
          bits: 8:8
          name: Enable_DST_SLV_ERR_IntStat
          desc: none
          resval: 0x1
          hwaccess: hro
          swaccess: rw
        }
        {
          bits: 9:9
          name: Enable_LLI_RD_DEC_ERR_IntStat
          desc: none
          resval: 0x1
          hwaccess: hro
          swaccess: rw
        }
        {
          bits: 10:10
          name: Enable_LLI_WR_DEC_ERR_IntStat
          desc: none
          resval: 0x1
          hwaccess: hro
          swaccess: rw
        }
        {
          bits: 11:11
          name: Enable_LLI_RD_SLV_ERR_IntStat
          desc: none
          resval: 0x1
          hwaccess: hro
          swaccess: rw
        }
        {
          bits: 12:12
          name: Enable_LLI_WR_SLV_ERR_IntStat
          desc: none
          resval: 0x1
          hwaccess: hro
          swaccess: rw
        }
        {
          bits: 13:13
          name: Enable_SHADOWREG_OR_LLI_INVALID_ERR_IntStat
          desc: none
          resval: 0x1
          hwaccess: hro
          swaccess: rw
        }
        {
          bits: 14:14
          name: Enable_SLVIF_MULTIBLKTYPE_ERR_IntStat
          desc: none
          resval: 0x1
          hwaccess: hro
          swaccess: rw
        }
        {
          bits: 15:15
          name: RSVD_DMAC_CHx_INTSTATUS_ENABLEREG_15
          desc: none
          resval: 0x1
          hwaccess: hro
          swaccess: ro
        }
        {
          bits: 16:16
          name: Enable_SLVIF_DEC_ERR_IntStat
          desc: none
          resval: 0x1
          hwaccess: hro
          swaccess: rw
        }
        {
          bits: 17:17
          name: Enable_SLVIF_WR2RO_ERR_IntStat
          desc: none
          resval: 0x1
          hwaccess: hro
          swaccess: rw
        }
        {
          bits: 18:18
          name: Enable_SLVIF_RD2RWO_ERR_IntStat
          desc: none
          resval: 0x1
          hwaccess: hro
          swaccess: rw
        }
        {
          bits: 19:19
          name: Enable_SLVIF_WRONCHEN_ERR_IntStat
          desc: none
          resval: 0x1
          hwaccess: hro
          swaccess: rw
        }
        {
          bits: 20:20
          name: Enable_SLVIF_SHADOWREG_WRON_VALID_ERR_IntStat
          desc: none
          resval: 0x1
          hwaccess: hro
          swaccess: rw
        }
        {
          bits: 21:21
          name: Enable_SLVIF_WRONHOLD_ERR_IntStat
          desc: none
          resval: 0x1
          hwaccess: hro
          swaccess: rw
        }
        {
          bits: 23:22
          name: RSVD_DMAC_CHx_INTSTATUS_ENABLEREG_22to23
          desc: none
          resval: 0x3
          hwaccess: hro
          swaccess: ro
        }
        {
          bits: 24:24
          name: Enable_SLVIF_ADDRPARITY_ERR_IntStat
          desc: none
          resval: 0x1
          hwaccess: hro
          swaccess: ro
        }
        {
          bits: 25:25
          name: Enable_SLVIF_WRPARITY_ERR_IntStat
          desc: none
          resval: 0x1
          hwaccess: hro
          swaccess: ro
        }
        {
          bits: 26:26
          name: RSVD_DMAC_CHx_INTSTATUS_ENABLEREG_26
          desc: none
          resval: 0x1
          hwaccess: hro
          swaccess: ro
        }
        {
          bits: 27:27
          name: Enable_CH_LOCK_CLEARED_IntStat
          desc: none
          resval: 0x1
          hwaccess: hro
          swaccess: rw
        }
        {
          bits: 28:28
          name: Enable_CH_SRC_SUSPENDED_IntStat
          desc: none
          resval: 0x1
          hwaccess: hro
          swaccess: rw
        }
        {
          bits: 29:29
          name: Enable_CH_SUSPENDED_IntStat
          desc: none
          resval: 0x1
          hwaccess: hro
          swaccess: rw
        }
        {
          bits: 30:30
          name: Enable_CH_DISABLED_IntStat
          desc: none
          resval: 0x1
          hwaccess: hro
          swaccess: rw
        }
        {
          bits: 31:31
          name: Enable_CH_ABORTED_IntStat
          desc: none
          resval: 0x1
          hwaccess: hro
          swaccess: rw
        }
        {
          bits: 32:32
          name: Enable_ECC_PROT_CHMem_CorrERR_IntStat
          desc: none
          resval: 0x1
          hwaccess: hro
          swaccess: ro
        }
        {
          bits: 33:33
          name: Enable_ECC_PROT_CHMem_UnCorrERR_IntStat
          desc: none
          resval: 0x1
          hwaccess: hro
          swaccess: ro
        }
        {
          bits: 34:34
          name: Enable_ECC_PROT_UIDMem_CorrERR_IntStat
          desc: none
          resval: 0x1
          hwaccess: hro
          swaccess: ro
        }
        {
          bits: 35:35
          name: Enable_ECC_PROT_UIDMem_UnCorrERR_IntStat
          desc: none
          resval: 0x1
          hwaccess: hro
          swaccess: ro
        }
        {
          bits: 63:36
          name: RSVD_DMAC_CHx_INTSTATUS_ENABLEREG_32to63
          desc: none
          resval: 0xfffffff
          hwaccess: hro
          swaccess: ro
        }
      ]
      desc: none
    }
    {
      skipto: 0x288
    }
    {
      name: CH2_INTSTATUS
      fields:
      [
        {
          bits: 0:0
          name: BLOCK_TFR_DONE_IntStat
          desc: none
          resval: 0x0
          hwaccess: hrw
          swaccess: ro
        }
        {
          bits: 1:1
          name: DMA_TFR_DONE_IntStat
          desc: none
          resval: 0x0
          hwaccess: hrw
          swaccess: ro
        }
        {
          bits: 2:2
          name: RSVD_DMAC_CHx_INTSTATUSREG_2
          desc: none
          resval: 0x0
          hwaccess: hrw
          swaccess: ro
        }
        {
          bits: 3:3
          name: SRC_TRANSCOMP_IntStat
          desc: none
          resval: 0x0
          hwaccess: hrw
          swaccess: ro
        }
        {
          bits: 4:4
          name: DST_TRANSCOMP_IntStat
          desc: none
          resval: 0x0
          hwaccess: hrw
          swaccess: ro
        }
        {
          bits: 5:5
          name: SRC_DEC_ERR_IntStat
          desc: none
          resval: 0x0
          hwaccess: hrw
          swaccess: ro
        }
        {
          bits: 6:6
          name: DST_DEC_ERR_IntStat
          desc: none
          resval: 0x0
          hwaccess: hrw
          swaccess: ro
        }
        {
          bits: 7:7
          name: SRC_SLV_ERR_IntStat
          desc: none
          resval: 0x0
          hwaccess: hrw
          swaccess: ro
        }
        {
          bits: 8:8
          name: DST_SLV_ERR_IntStat
          desc: none
          resval: 0x0
          hwaccess: hrw
          swaccess: ro
        }
        {
          bits: 9:9
          name: LLI_RD_DEC_ERR_IntStat
          desc: none
          resval: 0x0
          hwaccess: hrw
          swaccess: ro
        }
        {
          bits: 10:10
          name: LLI_WR_DEC_ERR_IntStat
          desc: none
          resval: 0x0
          hwaccess: hrw
          swaccess: ro
        }
        {
          bits: 11:11
          name: LLI_RD_SLV_ERR_IntStat
          desc: none
          resval: 0x0
          hwaccess: hrw
          swaccess: ro
        }
        {
          bits: 12:12
          name: LLI_WR_SLV_ERR_IntStat
          desc: none
          resval: 0x0
          hwaccess: hrw
          swaccess: ro
        }
        {
          bits: 13:13
          name: SHADOWREG_OR_LLI_INVALID_ERR_IntStat
          desc: none
          resval: 0x0
          hwaccess: hrw
          swaccess: ro
        }
        {
          bits: 14:14
          name: SLVIF_MULTIBLKTYPE_ERR_IntStat
          desc: none
          resval: 0x0
          hwaccess: hrw
          swaccess: ro
        }
        {
          bits: 15:15
          name: RSVD_DMAC_CHx_INTSTATUSREG_15
          desc: none
          resval: 0x0
          hwaccess: hrw
          swaccess: ro
        }
        {
          bits: 16:16
          name: SLVIF_DEC_ERR_IntStat
          desc: none
          resval: 0x0
          hwaccess: hrw
          swaccess: ro
        }
        {
          bits: 17:17
          name: SLVIF_WR2RO_ERR_IntStat
          desc: none
          resval: 0x0
          hwaccess: hrw
          swaccess: ro
        }
        {
          bits: 18:18
          name: SLVIF_RD2RWO_ERR_IntStat
          desc: none
          resval: 0x0
          hwaccess: hrw
          swaccess: ro
        }
        {
          bits: 19:19
          name: SLVIF_WRONCHEN_ERR_IntStat
          desc: none
          resval: 0x0
          hwaccess: hrw
          swaccess: ro
        }
        {
          bits: 20:20
          name: SLVIF_SHADOWREG_WRON_VALID_ERR_IntStat
          desc: none
          resval: 0x0
          hwaccess: hrw
          swaccess: ro
        }
        {
          bits: 21:21
          name: SLVIF_WRONHOLD_ERR_IntStat
          desc: none
          resval: 0x0
          hwaccess: hrw
          swaccess: ro
        }
        {
          bits: 23:22
          name: RSVD_DMAC_CHx_INTSTATUSREG_22to23
          desc: none
          resval: 0x0
          hwaccess: hrw
          swaccess: ro
        }
        {
          bits: 24:24
          name: SLVIF_ADDRPARITY_ERR_IntStat
          desc: none
          resval: 0x0
          hwaccess: hrw
          swaccess: ro
        }
        {
          bits: 25:25
          name: SLVIF_WRPARITY_ERR_IntStat
          desc: none
          resval: 0x0
          hwaccess: hrw
          swaccess: ro
        }
        {
          bits: 26:26
          name: RSVD_DMAC_CHx_INTSTATUSREG_26
          desc: none
          resval: 0x0
          hwaccess: hrw
          swaccess: ro
        }
        {
          bits: 27:27
          name: CH_LOCK_CLEARED_IntStat
          desc: none
          resval: 0x0
          hwaccess: hrw
          swaccess: ro
        }
        {
          bits: 28:28
          name: CH_SRC_SUSPENDED_IntStat
          desc: none
          resval: 0x0
          hwaccess: hrw
          swaccess: ro
        }
        {
          bits: 29:29
          name: CH_SUSPENDED_IntStat
          desc: none
          resval: 0x0
          hwaccess: hrw
          swaccess: ro
        }
        {
          bits: 30:30
          name: CH_DISABLED_IntStat
          desc: none
          resval: 0x0
          hwaccess: hrw
          swaccess: ro
        }
        {
          bits: 31:31
          name: CH_ABORTED_IntStat
          desc: none
          resval: 0x0
          hwaccess: hrw
          swaccess: ro
        }
        {
          bits: 32:32
          name: ECC_PROT_CHMem_CorrERR_IntStat
          desc: none
          resval: 0x0
          hwaccess: hrw
          swaccess: ro
        }
        {
          bits: 33:33
          name: ECC_PROT_CHMem_UnCorrERR_IntStat
          desc: none
          resval: 0x0
          hwaccess: hrw
          swaccess: ro
        }
        {
          bits: 34:34
          name: ECC_PROT_UIDMem_CorrERR_IntStat
          desc: none
          resval: 0x0
          hwaccess: hrw
          swaccess: ro
        }
        {
          bits: 35:35
          name: ECC_PROT_UIDMem_UnCorrERR_IntStat
          desc: none
          resval: 0x0
          hwaccess: hrw
          swaccess: ro
        }
        {
          bits: 63:36
          name: RSVD_DMAC_CHx_INTSTATUSREG_36to63
          desc: none
          resval: 0x0
          hwaccess: hrw
          swaccess: ro
        }
      ]
      desc: none
      tags:
      [
        exc:CsrBitBashTest
      ]
    }
    {
      skipto: 0x290
    }
    {
      name: CH2_INTSIGNAL_ENABLEREG
      fields:
      [
        {
          bits: 0:0
          name: Enable_BLOCK_TFR_DONE_IntSignal
          desc: none
          resval: 0x1
          hwaccess: hro
          swaccess: rw
        }
        {
          bits: 1:1
          name: Enable_DMA_TFR_DONE_IntSignal
          desc: none
          resval: 0x1
          hwaccess: hro
          swaccess: rw
        }
        {
          bits: 2:2
          name: RSVD_DMAC_CHx_INTSTATUS_ENABLEREG_2
          desc: none
          resval: 0x1
          hwaccess: hro
          swaccess: ro
        }
        {
          bits: 3:3
          name: Enable_SRC_TRANSCOMP_IntSignal
          desc: none
          resval: 0x1
          hwaccess: hro
          swaccess: rw
        }
        {
          bits: 4:4
          name: Enable_DST_TRANSCOMP_IntSignal
          desc: none
          resval: 0x1
          hwaccess: hro
          swaccess: rw
        }
        {
          bits: 5:5
          name: Enable_SRC_DEC_ERR_IntSignal
          desc: none
          resval: 0x1
          hwaccess: hro
          swaccess: rw
        }
        {
          bits: 6:6
          name: Enable_DST_DEC_ERR_IntSignal
          desc: none
          resval: 0x1
          hwaccess: hro
          swaccess: rw
        }
        {
          bits: 7:7
          name: Enable_SRC_SLV_ERR_IntSignal
          desc: none
          resval: 0x1
          hwaccess: hro
          swaccess: rw
        }
        {
          bits: 8:8
          name: Enable_DST_SLV_ERR_IntSignal
          desc: none
          resval: 0x1
          hwaccess: hro
          swaccess: rw
        }
        {
          bits: 9:9
          name: Enable_LLI_RD_DEC_ERR_IntSignal
          desc: none
          resval: 0x1
          hwaccess: hro
          swaccess: rw
        }
        {
          bits: 10:10
          name: Enable_LLI_WR_DEC_ERR_IntSignal
          desc: none
          resval: 0x1
          hwaccess: hro
          swaccess: rw
        }
        {
          bits: 11:11
          name: Enable_LLI_RD_SLV_ERR_IntSignal
          desc: none
          resval: 0x1
          hwaccess: hro
          swaccess: rw
        }
        {
          bits: 12:12
          name: Enable_LLI_WR_SLV_ERR_IntSignal
          desc: none
          resval: 0x1
          hwaccess: hro
          swaccess: rw
        }
        {
          bits: 13:13
          name: Enable_SHADOWREG_OR_LLI_INVALID_ERR_IntSignal
          desc: none
          resval: 0x1
          hwaccess: hro
          swaccess: rw
        }
        {
          bits: 14:14
          name: Enable_SLVIF_MULTIBLKTYPE_ERR_IntSignal
          desc: none
          resval: 0x1
          hwaccess: hro
          swaccess: rw
        }
        {
          bits: 15:15
          name: RSVD_DMAC_CHx_INTSTATUS_ENABLEREG_15
          desc: none
          resval: 0x1
          hwaccess: hro
          swaccess: ro
        }
        {
          bits: 16:16
          name: Enable_SLVIF_DEC_ERR_IntSignal
          desc: none
          resval: 0x1
          hwaccess: hro
          swaccess: rw
        }
        {
          bits: 17:17
          name: Enable_SLVIF_WR2RO_ERR_IntSignal
          desc: none
          resval: 0x1
          hwaccess: hro
          swaccess: rw
        }
        {
          bits: 18:18
          name: Enable_SLVIF_RD2RWO_ERR_IntSignal
          desc: none
          resval: 0x1
          hwaccess: hro
          swaccess: rw
        }
        {
          bits: 19:19
          name: Enable_SLVIF_WRONCHEN_ERR_IntSignal
          desc: none
          resval: 0x1
          hwaccess: hro
          swaccess: rw
        }
        {
          bits: 20:20
          name: Enable_SLVIF_SHADOWREG_WRON_VALID_ERR_IntSignal
          desc: none
          resval: 0x1
          hwaccess: hro
          swaccess: rw
        }
        {
          bits: 21:21
          name: Enable_SLVIF_WRONHOLD_ERR_IntSignal
          desc: none
          resval: 0x1
          hwaccess: hro
          swaccess: rw
        }
        {
          bits: 23:22
          name: RSVD_DMAC_CHx_INTSIGNAL_ENABLEREG_22to23
          desc: none
          resval: 0x3
          hwaccess: hro
          swaccess: ro
        }
        {
          bits: 24:24
          name: Enable_SLVIF_ADDRPARITY_ERR_IntSignal
          desc: none
          resval: 0x1
          hwaccess: hro
          swaccess: ro
        }
        {
          bits: 25:25
          name: Enable_SLVIF_WRPARITY_ERR_IntSignal
          desc: none
          resval: 0x1
          hwaccess: hro
          swaccess: ro
        }
        {
          bits: 26:26
          name: RSVD_DMAC_CHx_INTSIGNAL_ENABLEREG_26
          desc: none
          resval: 0x1
          hwaccess: hro
          swaccess: ro
        }
        {
          bits: 27:27
          name: Enable_CH_LOCK_CLEARED_IntSignal
          desc: none
          resval: 0x1
          hwaccess: hro
          swaccess: rw
        }
        {
          bits: 28:28
          name: Enable_CH_SRC_SUSPENDED_IntSignal
          desc: none
          resval: 0x1
          hwaccess: hro
          swaccess: rw
        }
        {
          bits: 29:29
          name: Enable_CH_SUSPENDED_IntSignal
          desc: none
          resval: 0x1
          hwaccess: hro
          swaccess: rw
        }
        {
          bits: 30:30
          name: Enable_CH_DISABLED_IntSignal
          desc: none
          resval: 0x1
          hwaccess: hro
          swaccess: rw
        }
        {
          bits: 31:31
          name: Enable_CH_ABORTED_IntSignal
          desc: none
          resval: 0x1
          hwaccess: hro
          swaccess: rw
        }
        {
          bits: 32:32
          name: Enable_ECC_PROT_CHMem_CorrERR_IntSignal
          desc: none
          resval: 0x1
          hwaccess: hro
          swaccess: ro
        }
        {
          bits: 33:33
          name: Enable_ECC_PROT_CHMem_UnCorrERR_IntSignal
          desc: none
          resval: 0x1
          hwaccess: hro
          swaccess: ro
        }
        {
          bits: 34:34
          name: Enable_ECC_PROT_UIDMem_CorrERR_IntSignal
          desc: none
          resval: 0x1
          hwaccess: hro
          swaccess: ro
        }
        {
          bits: 35:35
          name: Enable_ECC_PROT_UIDMem_UnCorrERR_IntSignal
          desc: none
          resval: 0x1
          hwaccess: hro
          swaccess: ro
        }
        {
          bits: 63:36
          name: RSVD_DMAC_CHx_INTSIGNAL_ENABLEREG_36to63
          desc: none
          resval: 0xfffffff
          hwaccess: hro
          swaccess: ro
        }
      ]
      desc: none
    }
    {
      skipto: 0x298
    }
    {
      name: CH2_INTCLEARREG
      fields:
      [
        {
          bits: 0:0
          name: Clear_BLOCK_TFR_DONE_IntStat
          desc: none
          resval: 0x0
          hwaccess: hro
          swaccess: wo
        }
        {
          bits: 1:1
          name: Clear_DMA_TFR_DONE_IntStat
          desc: none
          resval: 0x0
          hwaccess: hro
          swaccess: wo
        }
        {
          bits: 2:2
          name: RSVD_DMAC_CHx_INTCLEARREG_2
          desc: none
          resval: 0x0
          hwaccess: hro
          swaccess: wo
        }
        {
          bits: 3:3
          name: Clear_SRC_TRANSCOMP_IntStat
          desc: none
          resval: 0x0
          hwaccess: hro
          swaccess: wo
        }
        {
          bits: 4:4
          name: Clear_DST_TRANSCOMP_IntStat
          desc: none
          resval: 0x0
          hwaccess: hro
          swaccess: wo
        }
        {
          bits: 5:5
          name: Clear_SRC_DEC_ERR_IntStat
          desc: none
          resval: 0x0
          hwaccess: hro
          swaccess: wo
        }
        {
          bits: 6:6
          name: Clear_DST_DEC_ERR_IntStat
          desc: none
          resval: 0x0
          hwaccess: hro
          swaccess: wo
        }
        {
          bits: 7:7
          name: Clear_SRC_SLV_ERR_IntStat
          desc: none
          resval: 0x0
          hwaccess: hro
          swaccess: wo
        }
        {
          bits: 8:8
          name: Clear_DST_SLV_ERR_IntStat
          desc: none
          resval: 0x0
          hwaccess: hro
          swaccess: wo
        }
        {
          bits: 9:9
          name: Clear_LLI_RD_DEC_ERR_IntStat
          desc: none
          resval: 0x0
          hwaccess: hro
          swaccess: wo
        }
        {
          bits: 10:10
          name: Clear_LLI_WR_DEC_ERR_IntStat
          desc: none
          resval: 0x0
          hwaccess: hro
          swaccess: wo
        }
        {
          bits: 11:11
          name: Clear_LLI_RD_SLV_ERR_IntStat
          desc: none
          resval: 0x0
          hwaccess: hro
          swaccess: wo
        }
        {
          bits: 12:12
          name: Clear_LLI_WR_SLV_ERR_IntStat
          desc: none
          resval: 0x0
          hwaccess: hro
          swaccess: wo
        }
        {
          bits: 13:13
          name: Clear_SHADOWREG_OR_LLI_INVALID_ERR_IntStat
          desc: none
          resval: 0x0
          hwaccess: hro
          swaccess: wo
        }
        {
          bits: 14:14
          name: Clear_SLVIF_MULTIBLKTYPE_ERR_IntStat
          desc: none
          resval: 0x0
          hwaccess: hro
          swaccess: wo
        }
        {
          bits: 15:15
          name: RSVD_DMAC_CHx_INTCLEARREG_15
          desc: none
          resval: 0x0
          hwaccess: hro
          swaccess: wo
        }
        {
          bits: 16:16
          name: Clear_SLVIF_DEC_ERR_IntStat
          desc: none
          resval: 0x0
          hwaccess: hro
          swaccess: wo
        }
        {
          bits: 17:17
          name: Clear_SLVIF_WR2RO_ERR_IntStat
          desc: none
          resval: 0x0
          hwaccess: hro
          swaccess: wo
        }
        {
          bits: 18:18
          name: Clear_SLVIF_RD2RWO_ERR_IntStat
          desc: none
          resval: 0x0
          hwaccess: hro
          swaccess: wo
        }
        {
          bits: 19:19
          name: Clear_SLVIF_WRONCHEN_ERR_IntStat
          desc: none
          resval: 0x0
          hwaccess: hro
          swaccess: wo
        }
        {
          bits: 20:20
          name: Clear_SLVIF_SHADOWREG_WRON_VALID_ERR_IntStat
          desc: none
          resval: 0x0
          hwaccess: hro
          swaccess: wo
        }
        {
          bits: 21:21
          name: Clear_SLVIF_WRONHOLD_ERR_IntStat
          desc: none
          resval: 0x0
          hwaccess: hro
          swaccess: wo
        }
        {
          bits: 23:22
          name: RSVD_DMAC_CHx_INTCLEARREG_22to23
          desc: none
          resval: 0x0
          hwaccess: hro
          swaccess: wo
        }
        {
          bits: 24:24
          name: Clear_SLVIF_ADDRPARITY_ERR_IntStat
          desc: none
          resval: 0x0
          hwaccess: hro
          swaccess: wo
        }
        {
          bits: 25:25
          name: Clear_SLVIF_WRPARITY_ERR_IntStat
          desc: none
          resval: 0x0
          hwaccess: hro
          swaccess: wo
        }
        {
          bits: 26:26
          name: RSVD_DMAC_CHx_INTCLEARREG_26
          desc: none
          resval: 0x0
          hwaccess: hro
          swaccess: wo
        }
        {
          bits: 27:27
          name: Clear_CH_LOCK_CLEARED_IntStat
          desc: none
          resval: 0x0
          hwaccess: hro
          swaccess: wo
        }
        {
          bits: 28:28
          name: Clear_CH_SRC_SUSPENDED_IntStat
          desc: none
          resval: 0x0
          hwaccess: hro
          swaccess: wo
        }
        {
          bits: 29:29
          name: Clear_CH_SUSPENDED_IntStat
          desc: none
          resval: 0x0
          hwaccess: hro
          swaccess: wo
        }
        {
          bits: 30:30
          name: Clear_CH_DISABLED_IntStat
          desc: none
          resval: 0x0
          hwaccess: hro
          swaccess: wo
        }
        {
          bits: 31:31
          name: Clear_CH_ABORTED_IntStat
          desc: none
          resval: 0x0
          hwaccess: hro
          swaccess: wo
        }
        {
          bits: 32:32
          name: Clear_ECC_PROT_CHMem_CorrERR_IntStat
          desc: none
          resval: 0x0
          hwaccess: hro
          swaccess: wo
        }
        {
          bits: 33:33
          name: Clear_ECC_PROT_CHMem_UnCorrERR_IntStat
          desc: none
          resval: 0x0
          hwaccess: hro
          swaccess: wo
        }
        {
          bits: 34:34
          name: Clear_ECC_PROT_UIDMem_CorrERR_IntStat
          desc: none
          resval: 0x0
          hwaccess: hro
          swaccess: wo
        }
        {
          bits: 35:35
          name: Clear_ECC_PROT_UIDMem_UnCorrERR_IntStat
          desc: none
          resval: 0x0
          hwaccess: hro
          swaccess: wo
        }
        {
          bits: 63:36
          name: RSVD_DMAC_CHx_INTCLEARREG_36to63
          desc: none
          resval: 0x0
          hwaccess: hro
          swaccess: wo
        }
      ]
      desc: none
      tags:
      [
        exc:CsrAllTests
      ]
    }
    {
      skipto: 0x2a0
    }
    {
      name: CH2_CFG_EXTD
      fields:
      [
        {
          bits: 2:0
          name: LLI_AXPROT
          desc: none
          resval: 0x0
          hwaccess: hro
          swaccess: rw
        }
        {
          bits: 6:3
          name: LLI_AXCACHE
          desc: none
          resval: 0x0
          hwaccess: hro
          swaccess: rw
        }
        {
          bits: 63:7
          name: RSVD_DMAC_CHx_CFG_EXTD_7to63
          desc: none
          resval: 0x0
          hwaccess: hro
          swaccess: ro
        }
      ]
      desc: none
    }
  ]
}
