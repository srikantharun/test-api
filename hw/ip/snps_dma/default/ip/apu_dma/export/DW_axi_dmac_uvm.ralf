#
# ABSTRACT : RAL file generated for apu_DW_axi_dmac
#
block apu_DW_axi_dmac_mem_map_Common_Registers_Address_Block {
  endian little;
  bytes 8;
  register DMAC_IDREG @'h0 {
    field DMAC_ID @0 {
       bits 32;
       access ro;
       reset 32'h0;
    }
    field RSVD_DMAC_IDREG @32 {
       bits 32;
       access ro;
       reset 32'h0;
    }
    attributes { NO_REG_BIT_BASH_TEST 1 }
  }
  register DMAC_COMPVERREG @'h8 {
    field DMAC_COMPVER @0 {
       bits 32;
       access ro;
       reset 32'h3230332a;
    }
    field RSVD_DMAC_COMPVERREG @32 {
       bits 32;
       access ro;
       reset 32'h0;
    }
    attributes { NO_REG_BIT_BASH_TEST 1 }
  }
  register DMAC_CFGREG @'h10 {
    field DMAC_EN @0 {
       bits 1;
       access rw;
       reset 1'h0;
    }
    field INT_EN @1 {
       bits 1;
       access rw;
       reset 1'h0;
    }
    field RSVD_DMAC_CFGREG @2 {
       bits 62;
       access ro;
       reset 62'h0;
    }
  }
  register DMAC_CHENREG @'h18 {
    field CH1_EN @0 {
       bits 1;
       access rw;
       reset 1'h0;
      volatile 1;
    }
    field CH2_EN @1 {
       bits 1;
       access rw;
       reset 1'h0;
      volatile 1;
    }
    field RSVD_DMAC_CHENREG_CH_EN @2 {
       bits 6;
       access ro;
       reset 6'h0;
      volatile 1;
    }
    field CH1_EN_WE @8 {
       bits 1;
       access wo;
       reset 1'h0;
      volatile 1;
    }
    field CH2_EN_WE @9 {
       bits 1;
       access wo;
       reset 1'h0;
      volatile 1;
    }
    field RSVD_DMAC_CHENREG_CH_WE_EN @10 {
       bits 6;
       access ro;
       reset 6'h0;
      volatile 1;
    }
    field CH1_SUSP @16 {
       bits 1;
       access rw;
       reset 1'h0;
      volatile 1;
    }
    field CH2_SUSP @17 {
       bits 1;
       access rw;
       reset 1'h0;
      volatile 1;
    }
    field RSVD_DMAC_CHENREG_CH_SUSP @18 {
       bits 6;
       access ro;
       reset 6'h0;
      volatile 1;
    }
    field CH1_SUSP_WE @24 {
       bits 1;
       access wo;
       reset 1'h0;
      volatile 1;
    }
    field CH2_SUSP_WE @25 {
       bits 1;
       access wo;
       reset 1'h0;
      volatile 1;
    }
    field RSVD_DMAC_CHENREG_CH_SUSP_WE @26 {
       bits 6;
       access ro;
       reset 6'h0;
      volatile 1;
    }
    field CH1_ABORT @32 {
       bits 1;
       access ro;
       reset 1'h0;
      volatile 1;
    }
    field CH2_ABORT @33 {
       bits 1;
       access ro;
       reset 1'h0;
      volatile 1;
    }
    field RSVD_DMAC_CHENREG_CH_ABORT @34 {
       bits 6;
       access ro;
       reset 6'h0;
      volatile 1;
    }
    field CH1_ABORT_WE @40 {
       bits 1;
       access ro;
       reset 1'h0;
      volatile 1;
    }
    field CH2_ABORT_WE @41 {
       bits 1;
       access ro;
       reset 1'h0;
      volatile 1;
    }
    field RSVD_DMAC_CHENREG_CH_ABORT_WE @42 {
       bits 6;
       access ro;
       reset 6'h0;
      volatile 1;
    }
    field RSVD_DMAC_CHENREG @48 {
       bits 16;
       access ro;
       reset 16'h0;
      volatile 1;
    }
  }
  register DMAC_INTSTATUSREG @'h30 {
    field CH1_IntStat @0 {
       bits 1;
       access ro;
       reset 1'h0;
      volatile 1;
    }
    field CH2_IntStat @1 {
       bits 1;
       access ro;
       reset 1'h0;
      volatile 1;
    }
    field RSVD_DMAC_INTSTATUSREG_8to1 @2 {
       bits 6;
       access ro;
       reset 6'h0;
      volatile 1;
    }
    field RSVD_DMAC_INTSTATUSREG @8 {
       bits 8;
       access ro;
       reset 8'h0;
      volatile 1;
    }
    field CommonReg_IntStat @16 {
       bits 1;
       access ro;
       reset 1'h0;
      volatile 1;
    }
    field RSVD_DMAC_INTSTATUSREG_63to17 @17 {
       bits 47;
       access ro;
       reset 47'h0;
      volatile 1;
    }
    attributes { NO_REG_BIT_BASH_TEST 1 }
  }
  register DMAC_COMMONREG_INTCLEARREG @'h38 {
    field Clear_SLVIF_CommonReg_DEC_ERR_IntStat @0 {
       bits 1;
       access wo;
       reset 1'h0;
    }
    field Clear_SLVIF_CommonReg_WR2RO_ERR_IntStat @1 {
       bits 1;
       access wo;
       reset 1'h0;
    }
    field Clear_SLVIF_CommonReg_RD2WO_ERR_IntStat @2 {
       bits 1;
       access wo;
       reset 1'h0;
    }
    field Clear_SLVIF_CommonReg_WrOnHold_ERR_IntStat @3 {
       bits 1;
       access wo;
       reset 1'h0;
    }
    field RSVD_DMAC_COMMONREG_INTCLEARREG_4 @4 {
       bits 1;
       access wo;
       reset 1'h0;
    }
    field Clear_REGIF_Timeout_ERR_IntStat @5 {
       bits 1;
       access wo;
       reset 1'h0;
    }
    field Clear_REGIF_ADDRPARITY_ERR_IntStat @6 {
       bits 1;
       access wo;
       reset 1'h0;
    }
    field Clear_REGIF_WRPARITY_ERR_IntStat @7 {
       bits 1;
       access wo;
       reset 1'h0;
    }
    field Clear_SLVIF_UndefinedReg_DEC_ERR_IntStat @8 {
       bits 1;
       access wo;
       reset 1'h0;
    }
    field Clear_MXIF1_RCH0_PROT_CorrERR_IntStat @9 {
       bits 1;
       access wo;
       reset 1'h0;
    }
    field Clear_MXIF1_RCH0_PROT_UnCorrERR_IntStat @10 {
       bits 1;
       access wo;
       reset 1'h0;
    }
    field Clear_MXIF1_RCH1_PROT_CorrERR_IntStat @11 {
       bits 1;
       access wo;
       reset 1'h0;
    }
    field Clear_MXIF1_RCH1_PROT_UnCorrERR_IntStat @12 {
       bits 1;
       access wo;
       reset 1'h0;
    }
    field Clear_MXIF1_BCH_PROT_CorrERR_IntStat @13 {
       bits 1;
       access wo;
       reset 1'h0;
    }
    field Clear_MXIF1_BCH_PROT_UnCorrERR_IntStat @14 {
       bits 1;
       access wo;
       reset 1'h0;
    }
    field Clear_MXIF2_RCH0_PROT_CorrERR_IntStat @15 {
       bits 1;
       access wo;
       reset 1'h0;
    }
    field Clear_MXIF2_RCH0_PROT_UnCorrERR_IntStat @16 {
       bits 1;
       access wo;
       reset 1'h0;
    }
    field Clear_MXIF2_RCH1_PROT_CorrERR_IntStat @17 {
       bits 1;
       access wo;
       reset 1'h0;
    }
    field Clear_MXIF2_RCH1_PROT_UnCorrERR_IntStat @18 {
       bits 1;
       access wo;
       reset 1'h0;
    }
    field Clear_MXIF2_BCH_PROT_CorrERR_IntStat @19 {
       bits 1;
       access wo;
       reset 1'h0;
    }
    field Clear_MXIF2_BCH_PROT_UnCorrERR_IntStat @20 {
       bits 1;
       access wo;
       reset 1'h0;
    }
    field Clear_MXIF1_ARCH_PROT_ARREADY_ParErr_IntStat @21 {
       bits 1;
       access wo;
       reset 1'h0;
    }
    field Clear_MXIF1_AWCH_PROT_AWREADY_ParErr_IntStat @22 {
       bits 1;
       access wo;
       reset 1'h0;
    }
    field Clear_MXIF1_WCH_PROT_WREADY_ParErr_IntStat @23 {
       bits 1;
       access wo;
       reset 1'h0;
    }
    field Clear_MXIF1_RCH_PROT_RVALID_ParErr_IntStat @24 {
       bits 1;
       access wo;
       reset 1'h0;
    }
    field Clear_MXIF1_BCH_PROT_BVALID_ParErr_IntStat @25 {
       bits 1;
       access wo;
       reset 1'h0;
    }
    field Clear_MXIF2_ARCH_PROT_ARREADY_ParErr_IntStat @26 {
       bits 1;
       access wo;
       reset 1'h0;
    }
    field Clear_MXIF2_AWCH_PROT_AWREADY_ParErr_IntStat @27 {
       bits 1;
       access wo;
       reset 1'h0;
    }
    field Clear_MXIF2_WCH_PROT_WREADY_ParErr_IntStat @28 {
       bits 1;
       access wo;
       reset 1'h0;
    }
    field Clear_MXIF2_RCH_PROT_RVALID_ParErr_IntStat @29 {
       bits 1;
       access wo;
       reset 1'h0;
    }
    field Clear_MXIF2_BCH_PROT_BVALID_ParErr_IntStat @30 {
       bits 1;
       access wo;
       reset 1'h0;
    }
    field Clear_MXIF1_ARCH_PROT_Timeout_ERR_IntStat @31 {
       bits 1;
       access wo;
       reset 1'h0;
    }
    field Clear_MXIF1_AWCH_PROT_Timeout_ERR_IntStat @32 {
       bits 1;
       access wo;
       reset 1'h0;
    }
    field Clear_MXIF1_WCH_PROT_Timeout_ERR_IntStat @33 {
       bits 1;
       access wo;
       reset 1'h0;
    }
    field Clear_MXIF1_RCH_PROT_Timeout_ERR_IntStat @34 {
       bits 1;
       access wo;
       reset 1'h0;
    }
    field Clear_MXIF1_BCH_PROT_Timeout_ERR_IntStat @35 {
       bits 1;
       access wo;
       reset 1'h0;
    }
    field Clear_MXIF2_ARCH_PROT_Timeout_ERR_IntStat @36 {
       bits 1;
       access wo;
       reset 1'h0;
    }
    field Clear_MXIF2_AWCH_PROT_Timeout_ERR_IntStat @37 {
       bits 1;
       access wo;
       reset 1'h0;
    }
    field Clear_MXIF2_WCH_PROT_Timeout_ERR_IntStat @38 {
       bits 1;
       access wo;
       reset 1'h0;
    }
    field Clear_MXIF2_RCH_PROT_Timeout_ERR_IntStat @39 {
       bits 1;
       access wo;
       reset 1'h0;
    }
    field Clear_MXIF2_BCH_PROT_Timeout_ERR_IntStat @40 {
       bits 1;
       access wo;
       reset 1'h0;
    }
    field RSVD_DMAC_COMMONREG_INTCLEARREG_63to41 @41 {
       bits 23;
       access wo;
       reset 23'h0;
    }
    attributes { NO_REG_TESTS 1 }
  }
  register DMAC_COMMONREG_INTSTATUS_ENABLEREG @'h40 {
    field Enable_SLVIF_CommonReg_DEC_ERR_IntStat @0 {
       bits 1;
       access rw;
       reset 1'h1;
    }
    field Enable_SLVIF_CommonReg_WR2RO_ERR_IntStat @1 {
       bits 1;
       access rw;
       reset 1'h1;
    }
    field Enable_SLVIF_CommonReg_RD2WO_ERR_IntStat @2 {
       bits 1;
       access rw;
       reset 1'h1;
    }
    field Enable_SLVIF_CommonReg_WrOnHold_ERR_IntStat @3 {
       bits 1;
       access rw;
       reset 1'h1;
    }
    field RSVD_DMAC_COMMONREG_INTSTATUS_ENABLEREG_4 @4 {
       bits 1;
       access ro;
       reset 1'h1;
    }
    field Enable_REGIF_Timeout_ERR_IntStat @5 {
       bits 1;
       access ro;
       reset 1'h1;
    }
    field Enable_REGIF_ADDRPARITY_ERR_IntStat @6 {
       bits 1;
       access ro;
       reset 1'h1;
    }
    field Enable_REGIF_WRPARITY_ERR_IntStat @7 {
       bits 1;
       access ro;
       reset 1'h1;
    }
    field Enable_SLVIF_UndefinedReg_DEC_ERR_IntStat @8 {
       bits 1;
       access rw;
       reset 1'h1;
    }
    field Enable_MXIF1_RCH0_PROT_CorrERR_IntStat @9 {
       bits 1;
       access ro;
       reset 1'h1;
    }
    field Enable_MXIF1_RCH0_PROT_UnCorrERR_IntStat @10 {
       bits 1;
       access ro;
       reset 1'h1;
    }
    field Enable_MXIF1_RCH1_PROT_CorrERR_IntStat @11 {
       bits 1;
       access ro;
       reset 1'h1;
    }
    field Enable_MXIF1_RCH1_PROT_UnCorrERR_IntStat @12 {
       bits 1;
       access ro;
       reset 1'h1;
    }
    field Enable_MXIF1_BCH_PROT_CorrERR_IntStat @13 {
       bits 1;
       access ro;
       reset 1'h1;
    }
    field Enable_MXIF1_BCH_PROT_UnCorrERR_IntStat @14 {
       bits 1;
       access ro;
       reset 1'h1;
    }
    field Enable_MXIF2_RCH0_PROT_CorrERR_IntStat @15 {
       bits 1;
       access ro;
       reset 1'h1;
    }
    field Enable_MXIF2_RCH0_PROT_UnCorrERR_IntStat @16 {
       bits 1;
       access ro;
       reset 1'h1;
    }
    field Enable_MXIF2_RCH1_PROT_CorrERR_IntStat @17 {
       bits 1;
       access ro;
       reset 1'h1;
    }
    field Enable_MXIF2_RCH1_PROT_UnCorrERR_IntStat @18 {
       bits 1;
       access ro;
       reset 1'h1;
    }
    field Enable_MXIF2_BCH_PROT_CorrERR_IntStat @19 {
       bits 1;
       access ro;
       reset 1'h1;
    }
    field Enable_MXIF2_BCH_PROT_UnCorrERR_IntStat @20 {
       bits 1;
       access ro;
       reset 1'h1;
    }
    field Enable_MXIF1_ARCH_PROT_ARREADY_ParErr_IntStat @21 {
       bits 1;
       access ro;
       reset 1'h1;
    }
    field Enable_MXIF1_AWCH_PROT_AWREADY_ParErr_IntStat @22 {
       bits 1;
       access ro;
       reset 1'h1;
    }
    field Enable_MXIF1_WCH_PROT_WREADY_ParErr_IntStat @23 {
       bits 1;
       access ro;
       reset 1'h1;
    }
    field Enable_MXIF1_RCH_PROT_RVALID_ParErr_IntStat @24 {
       bits 1;
       access ro;
       reset 1'h1;
    }
    field Enable_MXIF1_BCH_PROT_BVALID_ParErr_IntStat @25 {
       bits 1;
       access ro;
       reset 1'h1;
    }
    field Enable_MXIF2_ARCH_PROT_ARREADY_ParErr_IntStat @26 {
       bits 1;
       access ro;
       reset 1'h1;
    }
    field Enable_MXIF2_AWCH_PROT_AWREADY_ParErr_IntStat @27 {
       bits 1;
       access ro;
       reset 1'h1;
    }
    field Enable_MXIF2_WCH_PROT_WREADY_ParErr_IntStat @28 {
       bits 1;
       access ro;
       reset 1'h1;
    }
    field Enable_MXIF2_RCH_PROT_RVALID_ParErr_IntStat @29 {
       bits 1;
       access ro;
       reset 1'h1;
    }
    field Enable_MXIF2_BCH_PROT_BVALID_ParErr_IntStat @30 {
       bits 1;
       access ro;
       reset 1'h1;
    }
    field Enable_MXIF1_ARCH_PROT_Timeout_ERR_IntStat @31 {
       bits 1;
       access ro;
       reset 1'h1;
    }
    field Enable_MXIF1_AWCH_PROT_Timeout_ERR_IntStat @32 {
       bits 1;
       access ro;
       reset 1'h1;
    }
    field Enable_MXIF1_WCH_PROT_Timeout_ERR_IntStat @33 {
       bits 1;
       access ro;
       reset 1'h1;
    }
    field Enable_MXIF1_RCH_PROT_Timeout_ERR_IntStat @34 {
       bits 1;
       access ro;
       reset 1'h1;
    }
    field Enable_MXIF1_BCH_PROT_Timeout_ERR_IntStat @35 {
       bits 1;
       access ro;
       reset 1'h1;
    }
    field Enable_MXIF2_ARCH_PROT_Timeout_ERR_IntStat @36 {
       bits 1;
       access ro;
       reset 1'h1;
    }
    field Enable_MXIF2_AWCH_PROT_Timeout_ERR_IntStat @37 {
       bits 1;
       access ro;
       reset 1'h1;
    }
    field Enable_MXIF2_WCH_PROT_Timeout_ERR_IntStat @38 {
       bits 1;
       access ro;
       reset 1'h1;
    }
    field Enable_MXIF2_RCH_PROT_Timeout_ERR_IntStat @39 {
       bits 1;
       access ro;
       reset 1'h1;
    }
    field Enable_MXIF2_BCH_PROT_Timeout_ERR_IntStat @40 {
       bits 1;
       access ro;
       reset 1'h1;
    }
    field RSVD_DMAC_COMMONREG_INTSTATUS_ENABLEREG_63to41 @41 {
       bits 23;
       access ro;
       reset 23'h7fffff;
    }
  }
  register DMAC_COMMONREG_INTSIGNAL_ENABLEREG @'h48 {
    field Enable_SLVIF_CommonReg_DEC_ERR_IntSignal @0 {
       bits 1;
       access rw;
       reset 1'h1;
    }
    field Enable_SLVIF_CommonReg_WR2RO_ERR_IntSignal @1 {
       bits 1;
       access rw;
       reset 1'h1;
    }
    field Enable_SLVIF_CommonReg_RD2WO_ERR_IntSignal @2 {
       bits 1;
       access rw;
       reset 1'h1;
    }
    field Enable_SLVIF_CommonReg_WrOnHold_ERR_IntSignal @3 {
       bits 1;
       access rw;
       reset 1'h1;
    }
    field RSVD_DMAC_COMMONREG_INTSIGNAL_ENABLEREG_4 @4 {
       bits 1;
       access ro;
       reset 1'h1;
    }
    field Enable_REGIF_Timeout_ERR_IntSignal @5 {
       bits 1;
       access ro;
       reset 1'h1;
    }
    field Enable_REGIF_ADDRPARITY_ERR_IntSignal @6 {
       bits 1;
       access ro;
       reset 1'h1;
    }
    field Enable_REGIF_WRPARITY_ERR_IntSignal @7 {
       bits 1;
       access ro;
       reset 1'h1;
    }
    field Enable_SLVIF_UndefinedReg_DEC_ERR_IntSignal @8 {
       bits 1;
       access rw;
       reset 1'h1;
    }
    field Enable_MXIF1_RCH0_PROT_CorrERR_IntSignal @9 {
       bits 1;
       access ro;
       reset 1'h1;
    }
    field Enable_MXIF1_RCH0_PROT_UnCorrERR_IntSignal @10 {
       bits 1;
       access ro;
       reset 1'h1;
    }
    field Enable_MXIF1_RCH1_PROT_CorrERR_IntSignal @11 {
       bits 1;
       access ro;
       reset 1'h1;
    }
    field Enable_MXIF1_RCH1_PROT_UnCorrERR_IntSignal @12 {
       bits 1;
       access ro;
       reset 1'h1;
    }
    field Enable_MXIF1_BCH_PROT_CorrERR_IntSignal @13 {
       bits 1;
       access ro;
       reset 1'h1;
    }
    field Enable_MXIF1_BCH_PROT_UnCorrERR_IntSignal @14 {
       bits 1;
       access ro;
       reset 1'h1;
    }
    field Enable_MXIF2_RCH0_PROT_CorrERR_IntSignal @15 {
       bits 1;
       access ro;
       reset 1'h1;
    }
    field Enable_MXIF2_RCH0_PROT_UnCorrERR_IntSignal @16 {
       bits 1;
       access ro;
       reset 1'h1;
    }
    field Enable_MXIF2_RCH1_PROT_CorrERR_IntSignal @17 {
       bits 1;
       access ro;
       reset 1'h1;
    }
    field Enable_MXIF2_RCH1_PROT_UnCorrERR_IntSignal @18 {
       bits 1;
       access ro;
       reset 1'h1;
    }
    field Enable_MXIF2_BCH_PROT_CorrERR_IntSignal @19 {
       bits 1;
       access ro;
       reset 1'h1;
    }
    field Enable_MXIF2_BCH_PROT_UnCorrERR_IntSignal @20 {
       bits 1;
       access ro;
       reset 1'h1;
    }
    field Enable_MXIF1_ARCH_PROT_ARREADY_ParErr_IntSignal @21 {
       bits 1;
       access ro;
       reset 1'h1;
    }
    field Enable_MXIF1_AWCH_PROT_AWREADY_ParErr_IntSignal @22 {
       bits 1;
       access ro;
       reset 1'h1;
    }
    field Enable_MXIF1_WCH_PROT_WREADY_ParErr_IntSignal @23 {
       bits 1;
       access ro;
       reset 1'h1;
    }
    field Enable_MXIF1_RCH_PROT_RVALID_ParErr_IntSignal @24 {
       bits 1;
       access ro;
       reset 1'h1;
    }
    field Enable_MXIF1_BCH_PROT_BVALID_ParErr_IntSignal @25 {
       bits 1;
       access ro;
       reset 1'h1;
    }
    field Enable_MXIF2_ARCH_PROT_ARREADY_ParErr_IntSignal @26 {
       bits 1;
       access ro;
       reset 1'h1;
    }
    field Enable_MXIF2_AWCH_PROT_AWREADY_ParErr_IntSignal @27 {
       bits 1;
       access ro;
       reset 1'h1;
    }
    field Enable_MXIF2_WCH_PROT_WREADY_ParErr_IntSignal @28 {
       bits 1;
       access ro;
       reset 1'h1;
    }
    field Enable_MXIF2_RCH_PROT_RVALID_ParErr_IntSignal @29 {
       bits 1;
       access ro;
       reset 1'h1;
    }
    field Enable_MXIF2_BCH_PROT_BVALID_ParErr_IntSignal @30 {
       bits 1;
       access ro;
       reset 1'h1;
    }
    field Enable_MXIF1_ARCH_PROT_Timeout_ERR_IntSignal @31 {
       bits 1;
       access ro;
       reset 1'h1;
    }
    field Enable_MXIF1_AWCH_PROT_Timeout_ERR_IntSignal @32 {
       bits 1;
       access ro;
       reset 1'h1;
    }
    field Enable_MXIF1_WCH_PROT_Timeout_ERR_IntSignal @33 {
       bits 1;
       access ro;
       reset 1'h1;
    }
    field Enable_MXIF1_RCH_PROT_Timeout_ERR_IntSignal @34 {
       bits 1;
       access ro;
       reset 1'h1;
    }
    field Enable_MXIF1_BCH_PROT_Timeout_ERR_IntSignal @35 {
       bits 1;
       access ro;
       reset 1'h1;
    }
    field Enable_MXIF2_ARCH_PROT_Timeout_ERR_IntSignal @36 {
       bits 1;
       access ro;
       reset 1'h1;
    }
    field Enable_MXIF2_AWCH_PROT_Timeout_ERR_IntSignal @37 {
       bits 1;
       access ro;
       reset 1'h1;
    }
    field Enable_MXIF2_WCH_PROT_Timeout_ERR_IntSignal @38 {
       bits 1;
       access ro;
       reset 1'h1;
    }
    field Enable_MXIF2_RCH_PROT_Timeout_ERR_IntSignal @39 {
       bits 1;
       access ro;
       reset 1'h1;
    }
    field Enable_MXIF2_BCH_PROT_Timeout_ERR_IntSignal @40 {
       bits 1;
       access ro;
       reset 1'h1;
    }
    field RSVD_DMAC_COMMONREG_INTSIGNAL_ENABLEREG_63to41 @41 {
       bits 23;
       access ro;
       reset 23'h7fffff;
    }
  }
  register DMAC_COMMONREG_INTSTATUSREG @'h50 {
    field SLVIF_CommonReg_DEC_ERR_IntStat @0 {
       bits 1;
       access ro;
       reset 1'h0;
      volatile 1;
    }
    field SLVIF_CommonReg_WR2RO_ERR_IntStat @1 {
       bits 1;
       access ro;
       reset 1'h0;
      volatile 1;
    }
    field SLVIF_CommonReg_RD2WO_ERR_IntStat @2 {
       bits 1;
       access ro;
       reset 1'h0;
      volatile 1;
    }
    field SLVIF_CommonReg_WrOnHold_ERR_IntStat @3 {
       bits 1;
       access ro;
       reset 1'h0;
      volatile 1;
    }
    field RSVD_DMAC_COMMONREG_INTSTATUSREG_4 @4 {
       bits 1;
       access ro;
       reset 1'h0;
      volatile 1;
    }
    field REGIF_Timeout_ERR_IntStat @5 {
       bits 1;
       access ro;
       reset 1'h0;
      volatile 1;
    }
    field REGIF_ADDRPARITY_ERR_IntStat @6 {
       bits 1;
       access ro;
       reset 1'h0;
      volatile 1;
    }
    field REGIF_WRPARITY_ERR_IntStat @7 {
       bits 1;
       access ro;
       reset 1'h0;
      volatile 1;
    }
    field SLVIF_UndefinedReg_DEC_ERR_IntStat @8 {
       bits 1;
       access ro;
       reset 1'h0;
      volatile 1;
    }
    field MXIF1_RCH0_PROT_CorrERR_IntStat @9 {
       bits 1;
       access ro;
       reset 1'h0;
      volatile 1;
    }
    field MXIF1_RCH0_PROT_UnCorrERR_IntStat @10 {
       bits 1;
       access ro;
       reset 1'h0;
      volatile 1;
    }
    field MXIF1_RCH1_PROT_CorrERR_IntStat @11 {
       bits 1;
       access ro;
       reset 1'h0;
      volatile 1;
    }
    field MXIF1_RCH1_PROT_UnCorrERR_IntStat @12 {
       bits 1;
       access ro;
       reset 1'h0;
      volatile 1;
    }
    field MXIF1_BCH_PROT_CorrERR_IntStat @13 {
       bits 1;
       access ro;
       reset 1'h0;
      volatile 1;
    }
    field MXIF1_BCH_PROT_UnCorrERR_IntStat @14 {
       bits 1;
       access ro;
       reset 1'h0;
      volatile 1;
    }
    field MXIF2_RCH0_PROT_CorrERR_IntStat @15 {
       bits 1;
       access ro;
       reset 1'h0;
      volatile 1;
    }
    field MXIF2_RCH0_PROT_UnCorrERR_IntStat @16 {
       bits 1;
       access ro;
       reset 1'h0;
      volatile 1;
    }
    field MXIF2_RCH1_PROT_CorrERR_IntStat @17 {
       bits 1;
       access ro;
       reset 1'h0;
      volatile 1;
    }
    field MXIF2_RCH1_PROT_UnCorrERR_IntStat @18 {
       bits 1;
       access ro;
       reset 1'h0;
      volatile 1;
    }
    field MXIF2_BCH_PROT_CorrERR_IntStat @19 {
       bits 1;
       access ro;
       reset 1'h0;
      volatile 1;
    }
    field MXIF2_BCH_PROT_UnCorrERR_IntStat @20 {
       bits 1;
       access ro;
       reset 1'h0;
      volatile 1;
    }
    field MXIF1_ARCH_PROT_ARREADY_ParErr_IntStat @21 {
       bits 1;
       access ro;
       reset 1'h0;
      volatile 1;
    }
    field MXIF1_AWCH_PROT_AWREADY_ParErr_IntStat @22 {
       bits 1;
       access ro;
       reset 1'h0;
      volatile 1;
    }
    field MXIF1_WCH_PROT_WREADY_ParErr_IntStat @23 {
       bits 1;
       access ro;
       reset 1'h0;
      volatile 1;
    }
    field MXIF1_RCH_PROT_RVALID_ParErr_IntStat @24 {
       bits 1;
       access ro;
       reset 1'h0;
      volatile 1;
    }
    field MXIF1_BCH_PROT_BVALID_ParErr_IntStat @25 {
       bits 1;
       access ro;
       reset 1'h0;
      volatile 1;
    }
    field MXIF2_ARCH_PROT_ARREADY_ParErr_IntStat @26 {
       bits 1;
       access ro;
       reset 1'h0;
      volatile 1;
    }
    field MXIF2_AWCH_PROT_AWREADY_ParErr_IntStat @27 {
       bits 1;
       access ro;
       reset 1'h0;
      volatile 1;
    }
    field MXIF2_WCH_PROT_WREADY_ParErr_IntStat @28 {
       bits 1;
       access ro;
       reset 1'h0;
      volatile 1;
    }
    field MXIF2_RCH_PROT_RVALID_ParErr_IntStat @29 {
       bits 1;
       access ro;
       reset 1'h0;
      volatile 1;
    }
    field MXIF2_BCH_PROT_BVALID_ParErr_IntStat @30 {
       bits 1;
       access ro;
       reset 1'h0;
      volatile 1;
    }
    field MXIF1_ARCH_PROT_Timeout_ERR_IntStat @31 {
       bits 1;
       access ro;
       reset 1'h0;
      volatile 1;
    }
    field MXIF1_AWCH_PROT_Timeout_ERR_IntStat @32 {
       bits 1;
       access ro;
       reset 1'h0;
      volatile 1;
    }
    field MXIF1_WCH_PROT_Timeout_ERR_IntStat @33 {
       bits 1;
       access ro;
       reset 1'h0;
      volatile 1;
    }
    field MXIF1_RCH_PROT_Timeout_ERR_IntStat @34 {
       bits 1;
       access ro;
       reset 1'h0;
      volatile 1;
    }
    field MXIF1_BCH_PROT_Timeout_ERR_IntStat @35 {
       bits 1;
       access ro;
       reset 1'h0;
      volatile 1;
    }
    field MXIF2_ARCH_PROT_Timeout_ERR_IntStat @36 {
       bits 1;
       access ro;
       reset 1'h0;
      volatile 1;
    }
    field MXIF2_AWCH_PROT_Timeout_ERR_IntStat @37 {
       bits 1;
       access ro;
       reset 1'h0;
      volatile 1;
    }
    field MXIF2_WCH_PROT_Timeout_ERR_IntStat @38 {
       bits 1;
       access ro;
       reset 1'h0;
      volatile 1;
    }
    field MXIF2_RCH_PROT_Timeout_ERR_IntStat @39 {
       bits 1;
       access ro;
       reset 1'h0;
      volatile 1;
    }
    field MXIF2_BCH_PROT_Timeout_ERR_IntStat @40 {
       bits 1;
       access ro;
       reset 1'h0;
      volatile 1;
    }
    field RSVD_DMAC_COMMONREG_INTSTATUSREG_63to41 @41 {
       bits 23;
       access ro;
       reset 23'h0;
      volatile 1;
    }
    attributes { NO_REG_BIT_BASH_TEST 1 }
  }
  register DMAC_RESETREG @'h58 {
    field DMAC_RST @0 {
       bits 1;
       access rw;
       reset 1'h0;
      volatile 1;
    }
    field CH_PRIOR_RST @1 {
       bits 1;
       access rw;
       reset 1'h0;
      volatile 1;
    }
    field VM_ID_RST @2 {
       bits 1;
       access rw;
       reset 1'h0;
      volatile 1;
    }
    field RSVD_DMAC_ResetReg_3to63 @3 {
       bits 61;
       access ro;
       reset 61'h0;
      volatile 1;
    }
  }
  register DMAC_LOWPOWER_CFGREG @'h60 {
    field GBL_CSLP_EN @0 {
       bits 1;
       access rw;
       reset 1'h1;
      volatile 1;
    }
    field CHNL_CSLP_EN @1 {
       bits 1;
       access rw;
       reset 1'h1;
      volatile 1;
    }
    field SBIU_CSLP_EN @2 {
       bits 1;
       access rw;
       reset 1'h1;
      volatile 1;
    }
    field MXIF_CSLP_EN @3 {
       bits 1;
       access rw;
       reset 1'h1;
      volatile 1;
    }
    field RSVD_DMAC_LOWPOWER_CFGREG_31to4 @4 {
       bits 28;
       access ro;
       reset 28'h0;
      volatile 1;
    }
    field GLCH_LPDLY @32 {
       bits 8;
       access rw;
       reset 8'h4;
      volatile 1;
    }
    field SBIU_LPDLY @40 {
       bits 8;
       access rw;
       reset 8'h4;
      volatile 1;
    }
    field MXIF_LPDLY @48 {
       bits 8;
       access rw;
       reset 8'h4;
      volatile 1;
    }
    field RSVD_DMAC_LOWPOWER_CFGREG_63to56 @56 {
       bits 8;
       access ro;
       reset 8'h0;
      volatile 1;
    }
  }
}
block apu_DW_axi_dmac_mem_map_Channel1_Registers_Address_Block {
  endian little;
  bytes 8;
  register CH1_SAR @'h0 {
    field SAR @0 {
       bits 64;
       access rw;
       reset 64'h0;
      volatile 1;
    }
  }
  register CH1_DAR @'h8 {
    field DAR @0 {
       bits 64;
       access rw;
       reset 64'h0;
      volatile 1;
    }
  }
  register CH1_BLOCK_TS @'h10 {
    field BLOCK_TS @0 {
       bits 22;
       access rw;
       reset 22'h0;
      volatile 1;
    }
    field RSVD_DMAC_CHx_BLOCK_TSREG_63to22 @22 {
       bits 42;
       access ro;
       reset 42'h0;
      volatile 1;
    }
  }
  register CH1_CTL @'h18 {
    field SMS @0 {
       bits 1;
       access ro;
       reset 1'h0;
    }
    field RSVD_DMAC_CHx_CTL_1 @1 {
       bits 1;
       access ro;
       reset 1'h0;
    }
    field DMS @2 {
       bits 1;
       access ro;
       reset 1'h0;
    }
    field RSVD_DMAC_CHx_CTL_3 @3 {
       bits 1;
       access ro;
       reset 1'h0;
    }
    field SINC @4 {
       bits 1;
       access rw;
       reset 1'h0;
    }
    field RSVD_DMAC_CHx_CTL_5 @5 {
       bits 1;
       access ro;
       reset 1'h0;
    }
    field DINC @6 {
       bits 1;
       access rw;
       reset 1'h0;
    }
    field CRC_EN @7 {
       bits 1;
       access ro;
       reset 1'h0;
    }
    field SRC_TR_WIDTH @8 {
       bits 3;
       access rw;
       reset 3'h2;
    }
    field DST_TR_WIDTH @11 {
       bits 3;
       access rw;
       reset 3'h2;
    }
    field SRC_MSIZE @14 {
       bits 4;
       access rw;
       reset 4'h0;
    }
    field DST_MSIZE @18 {
       bits 4;
       access rw;
       reset 4'h0;
    }
    field AR_CACHE @22 {
       bits 4;
       access rw;
       reset 4'h0;
    }
    field AW_CACHE @26 {
       bits 4;
       access rw;
       reset 4'h0;
    }
    field NonPosted_LastWrite_En @30 {
       bits 1;
       access rw;
       reset 1'h0;
    }
    field RSVD_DMAC_CHx_CTL_31 @31 {
       bits 1;
       access ro;
       reset 1'h0;
    }
    field AR_PROT @32 {
       bits 3;
       access rw;
       reset 3'h0;
    }
    field AW_PROT @35 {
       bits 3;
       access rw;
       reset 3'h0;
    }
    field ARLEN_EN @38 {
       bits 1;
       access rw;
       reset 1'h0;
    }
    field ARLEN @39 {
       bits 8;
       access rw;
       reset 8'h0;
    }
    field AWLEN_EN @47 {
       bits 1;
       access rw;
       reset 1'h0;
    }
    field AWLEN @48 {
       bits 8;
       access rw;
       reset 8'h0;
    }
    field SRC_STAT_EN @56 {
       bits 1;
       access ro;
       reset 1'h0;
    }
    field DST_STAT_EN @57 {
       bits 1;
       access ro;
       reset 1'h0;
    }
    field IOC_BlkTfr @58 {
       bits 1;
       access rw;
       reset 1'h0;
    }
    field RSVD_DMAC_CHx_CTL_59to61 @59 {
       bits 3;
       access ro;
       reset 3'h0;
    }
    field SHADOWREG_OR_LLI_LAST @62 {
       bits 1;
       access rw;
       reset 1'h0;
      volatile 1;
    }
    field SHADOWREG_OR_LLI_VALID @63 {
       bits 1;
       access rw;
       reset 1'h0;
      volatile 1;
    }
    attributes { NO_REG_BIT_BASH_TEST 1 }
  }
  register CH1_CFG @'h20 {
    field SRC_MULTBLK_TYPE @0 {
       bits 2;
       access rw;
       reset 2'h0;
      volatile 1;
    }
    field DST_MULTBLK_TYPE @2 {
       bits 2;
       access rw;
       reset 2'h0;
      volatile 1;
    }
    field RSVD_DMAC_CHx_CFG_4to16 @4 {
       bits 13;
       access ro;
       reset 13'h0;
      volatile 1;
    }
    field LLI_AUTO_RESUME_REQ_EN @17 {
       bits 1;
       access ro;
       reset 1'h0;
      volatile 1;
    }
    field RD_UID @18 {
       bits 3;
       access ro;
       reset 3'h0;
      volatile 1;
    }
    field RSVD_DMAC_CHx_CFG_21to24 @21 {
       bits 4;
       access ro;
       reset 4'h0;
      volatile 1;
    }
    field WR_UID @25 {
       bits 3;
       access ro;
       reset 3'h0;
      volatile 1;
    }
    field RSVD_DMAC_CHx_CFG_28to31 @28 {
       bits 4;
       access ro;
       reset 4'h0;
      volatile 1;
    }
    field TT_FC @32 {
       bits 3;
       access ro;
       reset 3'h0;
      volatile 1;
    }
    field HS_SEL_SRC @35 {
       bits 1;
       access rw;
       reset 1'h1;
      volatile 1;
    }
    field HS_SEL_DST @36 {
       bits 1;
       access rw;
       reset 1'h1;
      volatile 1;
    }
    field SRC_HWHS_POL @37 {
       bits 1;
       access ro;
       reset 1'h0;
      volatile 1;
    }
    field DST_HWHS_POL @38 {
       bits 1;
       access ro;
       reset 1'h0;
      volatile 1;
    }
    field SRC_PER @39 {
       bits 1;
       access ro;
       reset 1'h0;
      volatile 1;
    }
    field RSVD_DMAC_CHx_CFG_42_39 @40 {
       bits 3;
       access ro;
       reset 3'h0;
      volatile 1;
    }
    field RSVD_DMAC_CHx_CFG_43 @43 {
       bits 1;
       access ro;
       reset 1'h0;
      volatile 1;
    }
    field DST_PER @44 {
       bits 1;
       access ro;
       reset 1'h0;
      volatile 1;
    }
    field RSVD_DMAC_CHx_CFG_47_44 @45 {
       bits 3;
       access ro;
       reset 3'h0;
      volatile 1;
    }
    field RSVD_DMAC_CHx_CFG_48 @48 {
       bits 1;
       access ro;
       reset 1'h0;
      volatile 1;
    }
    field CH_PRIOR @49 {
       bits 3;
       access rw;
       reset 3'h1;
      volatile 1;
    }
    field LOCK_CH @52 {
       bits 1;
       access ro;
       reset 1'h0;
      volatile 1;
    }
    field LOCK_CH_L @53 {
       bits 2;
       access ro;
       reset 2'h0;
      volatile 1;
    }
    field SRC_OSR_LMT @55 {
       bits 4;
       access rw;
       reset 4'h0;
      volatile 1;
    }
    field DST_OSR_LMT @59 {
       bits 4;
       access rw;
       reset 4'h0;
      volatile 1;
    }
    field RSVD_DMAC_CHx_CFG_63 @63 {
       bits 1;
       access ro;
       reset 1'h0;
      volatile 1;
    }
  }
  register CH1_LLP @'h28 {
    field LMS @0 {
       bits 1;
       access ro;
       reset 1'h0;
      volatile 1;
    }
    field RSVD_DMAC_CHx_LLP_1to5 @1 {
       bits 5;
       access ro;
       reset 5'h0;
      volatile 1;
    }
    field LOC @6 {
       bits 58;
       access rw;
       reset 58'h0;
      volatile 1;
    }
  }
  register CH1_STATUSREG @'h30 {
    field CMPLTD_BLK_TFR_SIZE @0 {
       bits 22;
       access ro;
       reset 22'h0;
      volatile 1;
    }
    field RSVD_DMAC_CHx_STATUSREG_22to31 @22 {
       bits 10;
       access ro;
       reset 10'h0;
      volatile 1;
    }
    field DATA_LEFT_IN_FIFO @32 {
       bits 15;
       access ro;
       reset 15'h0;
      volatile 1;
    }
    field RSVD_DMAC_CHx_STATUSREG_47to63 @47 {
       bits 17;
       access ro;
       reset 17'h0;
      volatile 1;
    }
    attributes { NO_REG_BIT_BASH_TEST 1 }
  }
  register CH1_SWHSSRCREG @'h38 {
    field SWHS_REQ_SRC @0 {
       bits 1;
       access rw;
       reset 1'h0;
      volatile 1;
    }
    field SWHS_REQ_SRC_WE @1 {
       bits 1;
       access wo;
       reset 1'h0;
      volatile 1;
    }
    field SWHS_SGLREQ_SRC @2 {
       bits 1;
       access rw;
       reset 1'h0;
      volatile 1;
    }
    field SWHS_SGLREQ_SRC_WE @3 {
       bits 1;
       access wo;
       reset 1'h0;
      volatile 1;
    }
    field SWHS_LST_SRC @4 {
       bits 1;
       access rw;
       reset 1'h0;
      volatile 1;
    }
    field SWHS_LST_SRC_WE @5 {
       bits 1;
       access wo;
       reset 1'h0;
      volatile 1;
    }
    field RSVD_DMAC_CHx_SWHSSRCREG_6to63 @6 {
       bits 58;
       access ro;
       reset 58'h0;
      volatile 1;
    }
  }
  register CH1_SWHSDSTREG @'h40 {
    field SWHS_REQ_DST @0 {
       bits 1;
       access rw;
       reset 1'h0;
      volatile 1;
    }
    field SWHS_REQ_DST_WE @1 {
       bits 1;
       access wo;
       reset 1'h0;
      volatile 1;
    }
    field SWHS_SGLREQ_DST @2 {
       bits 1;
       access rw;
       reset 1'h0;
      volatile 1;
    }
    field SWHS_SGLREQ_DST_WE @3 {
       bits 1;
       access wo;
       reset 1'h0;
      volatile 1;
    }
    field SWHS_LST_DST @4 {
       bits 1;
       access rw;
       reset 1'h0;
      volatile 1;
    }
    field SWHS_LST_DST_WE @5 {
       bits 1;
       access wo;
       reset 1'h0;
      volatile 1;
    }
    field RSVD_DMAC_CHx_SWHSDSTREG_6to63 @6 {
       bits 58;
       access ro;
       reset 58'h0;
      volatile 1;
    }
  }
  register CH1_BLK_TFR_RESUMEREQREG @'h48 {
    field BLK_TFR_RESUMEREQ @0 {
       bits 1;
       access wo;
       reset 1'h0;
    }
    field RSVD_DMAC_CHx_BLK_TFR_RESUMEREQREG_1to63 @1 {
       bits 63;
       access wo;
       reset 63'h0;
    }
    attributes { NO_REG_TESTS 1 }
  }
  register CH1_AXI_IDREG @'h50 {
    field AXI_READ_ID_SUFFIX @0 {
       bits 6;
       access rw;
       reset 6'h0;
    }
    field RSVD_DMAC_CHx_AXI_IDREG_IDW_L2NCm1to31 @6 {
       bits 10;
       access ro;
       reset 10'h0;
    }
    field AXI_WRITE_ID_SUFFIX @16 {
       bits 6;
       access rw;
       reset 6'h0;
    }
    field RSVD_DMAC_CHx_AXI_IDREG_IDW_L2NCm32to63 @22 {
       bits 10;
       access ro;
       reset 10'h0;
    }
    field RSVD_DMAC_CHx_AXI_IDREG_32to63 @32 {
       bits 32;
       access ro;
       reset 32'h0;
    }
  }
  register CH1_AXI_QOSREG @'h58 {
    field AXI_AWQOS @0 {
       bits 4;
       access ro;
       reset 4'h0;
    }
    field AXI_ARQOS @4 {
       bits 4;
       access ro;
       reset 4'h0;
    }
    field RSVD_DMAC_CHx_AXI_QOSREG_8to63 @8 {
       bits 56;
       access ro;
       reset 56'h0;
    }
    attributes { NO_REG_BIT_BASH_TEST 1 }
  }
  register CH1_INTSTATUS_ENABLEREG @'h80 {
    field Enable_BLOCK_TFR_DONE_IntStat @0 {
       bits 1;
       access rw;
       reset 1'h1;
    }
    field Enable_DMA_TFR_DONE_IntStat @1 {
       bits 1;
       access rw;
       reset 1'h1;
    }
    field RSVD_DMAC_CHx_INTSTATUS_ENABLEREG_2 @2 {
       bits 1;
       access ro;
       reset 1'h1;
    }
    field Enable_SRC_TRANSCOMP_IntStat @3 {
       bits 1;
       access rw;
       reset 1'h1;
    }
    field Enable_DST_TRANSCOMP_IntStat @4 {
       bits 1;
       access rw;
       reset 1'h1;
    }
    field Enable_SRC_DEC_ERR_IntStat @5 {
       bits 1;
       access rw;
       reset 1'h1;
    }
    field Enable_DST_DEC_ERR_IntStat @6 {
       bits 1;
       access rw;
       reset 1'h1;
    }
    field Enable_SRC_SLV_ERR_IntStat @7 {
       bits 1;
       access rw;
       reset 1'h1;
    }
    field Enable_DST_SLV_ERR_IntStat @8 {
       bits 1;
       access rw;
       reset 1'h1;
    }
    field Enable_LLI_RD_DEC_ERR_IntStat @9 {
       bits 1;
       access rw;
       reset 1'h1;
    }
    field Enable_LLI_WR_DEC_ERR_IntStat @10 {
       bits 1;
       access rw;
       reset 1'h1;
    }
    field Enable_LLI_RD_SLV_ERR_IntStat @11 {
       bits 1;
       access rw;
       reset 1'h1;
    }
    field Enable_LLI_WR_SLV_ERR_IntStat @12 {
       bits 1;
       access rw;
       reset 1'h1;
    }
    field Enable_SHADOWREG_OR_LLI_INVALID_ERR_IntStat @13 {
       bits 1;
       access rw;
       reset 1'h1;
    }
    field Enable_SLVIF_MULTIBLKTYPE_ERR_IntStat @14 {
       bits 1;
       access rw;
       reset 1'h1;
    }
    field RSVD_DMAC_CHx_INTSTATUS_ENABLEREG_15 @15 {
       bits 1;
       access ro;
       reset 1'h1;
    }
    field Enable_SLVIF_DEC_ERR_IntStat @16 {
       bits 1;
       access rw;
       reset 1'h1;
    }
    field Enable_SLVIF_WR2RO_ERR_IntStat @17 {
       bits 1;
       access rw;
       reset 1'h1;
    }
    field Enable_SLVIF_RD2RWO_ERR_IntStat @18 {
       bits 1;
       access rw;
       reset 1'h1;
    }
    field Enable_SLVIF_WRONCHEN_ERR_IntStat @19 {
       bits 1;
       access rw;
       reset 1'h1;
    }
    field Enable_SLVIF_SHADOWREG_WRON_VALID_ERR_IntStat @20 {
       bits 1;
       access rw;
       reset 1'h1;
    }
    field Enable_SLVIF_WRONHOLD_ERR_IntStat @21 {
       bits 1;
       access rw;
       reset 1'h1;
    }
    field RSVD_DMAC_CHx_INTSTATUS_ENABLEREG_22to23 @22 {
       bits 2;
       access ro;
       reset 2'h3;
    }
    field Enable_SLVIF_ADDRPARITY_ERR_IntStat @24 {
       bits 1;
       access ro;
       reset 1'h1;
    }
    field Enable_SLVIF_WRPARITY_ERR_IntStat @25 {
       bits 1;
       access ro;
       reset 1'h1;
    }
    field RSVD_DMAC_CHx_INTSTATUS_ENABLEREG_26 @26 {
       bits 1;
       access ro;
       reset 1'h1;
    }
    field Enable_CH_LOCK_CLEARED_IntStat @27 {
       bits 1;
       access rw;
       reset 1'h1;
    }
    field Enable_CH_SRC_SUSPENDED_IntStat @28 {
       bits 1;
       access rw;
       reset 1'h1;
    }
    field Enable_CH_SUSPENDED_IntStat @29 {
       bits 1;
       access rw;
       reset 1'h1;
    }
    field Enable_CH_DISABLED_IntStat @30 {
       bits 1;
       access rw;
       reset 1'h1;
    }
    field Enable_CH_ABORTED_IntStat @31 {
       bits 1;
       access rw;
       reset 1'h1;
    }
    field Enable_ECC_PROT_CHMem_CorrERR_IntStat @32 {
       bits 1;
       access ro;
       reset 1'h1;
    }
    field Enable_ECC_PROT_CHMem_UnCorrERR_IntStat @33 {
       bits 1;
       access ro;
       reset 1'h1;
    }
    field Enable_ECC_PROT_UIDMem_CorrERR_IntStat @34 {
       bits 1;
       access ro;
       reset 1'h1;
    }
    field Enable_ECC_PROT_UIDMem_UnCorrERR_IntStat @35 {
       bits 1;
       access ro;
       reset 1'h1;
    }
    field RSVD_DMAC_CHx_INTSTATUS_ENABLEREG_32to63 @36 {
       bits 28;
       access ro;
       reset 28'hfffffff;
    }
  }
  register CH1_INTSTATUS @'h88 {
    field BLOCK_TFR_DONE_IntStat @0 {
       bits 1;
       access ro;
       reset 1'h0;
      volatile 1;
    }
    field DMA_TFR_DONE_IntStat @1 {
       bits 1;
       access ro;
       reset 1'h0;
      volatile 1;
    }
    field RSVD_DMAC_CHx_INTSTATUSREG_2 @2 {
       bits 1;
       access ro;
       reset 1'h0;
      volatile 1;
    }
    field SRC_TRANSCOMP_IntStat @3 {
       bits 1;
       access ro;
       reset 1'h0;
      volatile 1;
    }
    field DST_TRANSCOMP_IntStat @4 {
       bits 1;
       access ro;
       reset 1'h0;
      volatile 1;
    }
    field SRC_DEC_ERR_IntStat @5 {
       bits 1;
       access ro;
       reset 1'h0;
      volatile 1;
    }
    field DST_DEC_ERR_IntStat @6 {
       bits 1;
       access ro;
       reset 1'h0;
      volatile 1;
    }
    field SRC_SLV_ERR_IntStat @7 {
       bits 1;
       access ro;
       reset 1'h0;
      volatile 1;
    }
    field DST_SLV_ERR_IntStat @8 {
       bits 1;
       access ro;
       reset 1'h0;
      volatile 1;
    }
    field LLI_RD_DEC_ERR_IntStat @9 {
       bits 1;
       access ro;
       reset 1'h0;
      volatile 1;
    }
    field LLI_WR_DEC_ERR_IntStat @10 {
       bits 1;
       access ro;
       reset 1'h0;
      volatile 1;
    }
    field LLI_RD_SLV_ERR_IntStat @11 {
       bits 1;
       access ro;
       reset 1'h0;
      volatile 1;
    }
    field LLI_WR_SLV_ERR_IntStat @12 {
       bits 1;
       access ro;
       reset 1'h0;
      volatile 1;
    }
    field SHADOWREG_OR_LLI_INVALID_ERR_IntStat @13 {
       bits 1;
       access ro;
       reset 1'h0;
      volatile 1;
    }
    field SLVIF_MULTIBLKTYPE_ERR_IntStat @14 {
       bits 1;
       access ro;
       reset 1'h0;
      volatile 1;
    }
    field RSVD_DMAC_CHx_INTSTATUSREG_15 @15 {
       bits 1;
       access ro;
       reset 1'h0;
      volatile 1;
    }
    field SLVIF_DEC_ERR_IntStat @16 {
       bits 1;
       access ro;
       reset 1'h0;
      volatile 1;
    }
    field SLVIF_WR2RO_ERR_IntStat @17 {
       bits 1;
       access ro;
       reset 1'h0;
      volatile 1;
    }
    field SLVIF_RD2RWO_ERR_IntStat @18 {
       bits 1;
       access ro;
       reset 1'h0;
      volatile 1;
    }
    field SLVIF_WRONCHEN_ERR_IntStat @19 {
       bits 1;
       access ro;
       reset 1'h0;
      volatile 1;
    }
    field SLVIF_SHADOWREG_WRON_VALID_ERR_IntStat @20 {
       bits 1;
       access ro;
       reset 1'h0;
      volatile 1;
    }
    field SLVIF_WRONHOLD_ERR_IntStat @21 {
       bits 1;
       access ro;
       reset 1'h0;
      volatile 1;
    }
    field RSVD_DMAC_CHx_INTSTATUSREG_22to23 @22 {
       bits 2;
       access ro;
       reset 2'h0;
      volatile 1;
    }
    field SLVIF_ADDRPARITY_ERR_IntStat @24 {
       bits 1;
       access ro;
       reset 1'h0;
      volatile 1;
    }
    field SLVIF_WRPARITY_ERR_IntStat @25 {
       bits 1;
       access ro;
       reset 1'h0;
      volatile 1;
    }
    field RSVD_DMAC_CHx_INTSTATUSREG_26 @26 {
       bits 1;
       access ro;
       reset 1'h0;
      volatile 1;
    }
    field CH_LOCK_CLEARED_IntStat @27 {
       bits 1;
       access ro;
       reset 1'h0;
      volatile 1;
    }
    field CH_SRC_SUSPENDED_IntStat @28 {
       bits 1;
       access ro;
       reset 1'h0;
      volatile 1;
    }
    field CH_SUSPENDED_IntStat @29 {
       bits 1;
       access ro;
       reset 1'h0;
      volatile 1;
    }
    field CH_DISABLED_IntStat @30 {
       bits 1;
       access ro;
       reset 1'h0;
      volatile 1;
    }
    field CH_ABORTED_IntStat @31 {
       bits 1;
       access ro;
       reset 1'h0;
      volatile 1;
    }
    field ECC_PROT_CHMem_CorrERR_IntStat @32 {
       bits 1;
       access ro;
       reset 1'h0;
      volatile 1;
    }
    field ECC_PROT_CHMem_UnCorrERR_IntStat @33 {
       bits 1;
       access ro;
       reset 1'h0;
      volatile 1;
    }
    field ECC_PROT_UIDMem_CorrERR_IntStat @34 {
       bits 1;
       access ro;
       reset 1'h0;
      volatile 1;
    }
    field ECC_PROT_UIDMem_UnCorrERR_IntStat @35 {
       bits 1;
       access ro;
       reset 1'h0;
      volatile 1;
    }
    field RSVD_DMAC_CHx_INTSTATUSREG_36to63 @36 {
       bits 28;
       access ro;
       reset 28'h0;
      volatile 1;
    }
    attributes { NO_REG_BIT_BASH_TEST 1 }
  }
  register CH1_INTSIGNAL_ENABLEREG @'h90 {
    field Enable_BLOCK_TFR_DONE_IntSignal @0 {
       bits 1;
       access rw;
       reset 1'h1;
    }
    field Enable_DMA_TFR_DONE_IntSignal @1 {
       bits 1;
       access rw;
       reset 1'h1;
    }
    field RSVD_DMAC_CHx_INTSTATUS_ENABLEREG_2 @2 {
       bits 1;
       access ro;
       reset 1'h1;
    }
    field Enable_SRC_TRANSCOMP_IntSignal @3 {
       bits 1;
       access rw;
       reset 1'h1;
    }
    field Enable_DST_TRANSCOMP_IntSignal @4 {
       bits 1;
       access rw;
       reset 1'h1;
    }
    field Enable_SRC_DEC_ERR_IntSignal @5 {
       bits 1;
       access rw;
       reset 1'h1;
    }
    field Enable_DST_DEC_ERR_IntSignal @6 {
       bits 1;
       access rw;
       reset 1'h1;
    }
    field Enable_SRC_SLV_ERR_IntSignal @7 {
       bits 1;
       access rw;
       reset 1'h1;
    }
    field Enable_DST_SLV_ERR_IntSignal @8 {
       bits 1;
       access rw;
       reset 1'h1;
    }
    field Enable_LLI_RD_DEC_ERR_IntSignal @9 {
       bits 1;
       access rw;
       reset 1'h1;
    }
    field Enable_LLI_WR_DEC_ERR_IntSignal @10 {
       bits 1;
       access rw;
       reset 1'h1;
    }
    field Enable_LLI_RD_SLV_ERR_IntSignal @11 {
       bits 1;
       access rw;
       reset 1'h1;
    }
    field Enable_LLI_WR_SLV_ERR_IntSignal @12 {
       bits 1;
       access rw;
       reset 1'h1;
    }
    field Enable_SHADOWREG_OR_LLI_INVALID_ERR_IntSignal @13 {
       bits 1;
       access rw;
       reset 1'h1;
    }
    field Enable_SLVIF_MULTIBLKTYPE_ERR_IntSignal @14 {
       bits 1;
       access rw;
       reset 1'h1;
    }
    field RSVD_DMAC_CHx_INTSTATUS_ENABLEREG_15 @15 {
       bits 1;
       access ro;
       reset 1'h1;
    }
    field Enable_SLVIF_DEC_ERR_IntSignal @16 {
       bits 1;
       access rw;
       reset 1'h1;
    }
    field Enable_SLVIF_WR2RO_ERR_IntSignal @17 {
       bits 1;
       access rw;
       reset 1'h1;
    }
    field Enable_SLVIF_RD2RWO_ERR_IntSignal @18 {
       bits 1;
       access rw;
       reset 1'h1;
    }
    field Enable_SLVIF_WRONCHEN_ERR_IntSignal @19 {
       bits 1;
       access rw;
       reset 1'h1;
    }
    field Enable_SLVIF_SHADOWREG_WRON_VALID_ERR_IntSignal @20 {
       bits 1;
       access rw;
       reset 1'h1;
    }
    field Enable_SLVIF_WRONHOLD_ERR_IntSignal @21 {
       bits 1;
       access rw;
       reset 1'h1;
    }
    field RSVD_DMAC_CHx_INTSIGNAL_ENABLEREG_22to23 @22 {
       bits 2;
       access ro;
       reset 2'h3;
    }
    field Enable_SLVIF_ADDRPARITY_ERR_IntSignal @24 {
       bits 1;
       access ro;
       reset 1'h1;
    }
    field Enable_SLVIF_WRPARITY_ERR_IntSignal @25 {
       bits 1;
       access ro;
       reset 1'h1;
    }
    field RSVD_DMAC_CHx_INTSIGNAL_ENABLEREG_26 @26 {
       bits 1;
       access ro;
       reset 1'h1;
    }
    field Enable_CH_LOCK_CLEARED_IntSignal @27 {
       bits 1;
       access rw;
       reset 1'h1;
    }
    field Enable_CH_SRC_SUSPENDED_IntSignal @28 {
       bits 1;
       access rw;
       reset 1'h1;
    }
    field Enable_CH_SUSPENDED_IntSignal @29 {
       bits 1;
       access rw;
       reset 1'h1;
    }
    field Enable_CH_DISABLED_IntSignal @30 {
       bits 1;
       access rw;
       reset 1'h1;
    }
    field Enable_CH_ABORTED_IntSignal @31 {
       bits 1;
       access rw;
       reset 1'h1;
    }
    field Enable_ECC_PROT_CHMem_CorrERR_IntSignal @32 {
       bits 1;
       access ro;
       reset 1'h1;
    }
    field Enable_ECC_PROT_CHMem_UnCorrERR_IntSignal @33 {
       bits 1;
       access ro;
       reset 1'h1;
    }
    field Enable_ECC_PROT_UIDMem_CorrERR_IntSignal @34 {
       bits 1;
       access ro;
       reset 1'h1;
    }
    field Enable_ECC_PROT_UIDMem_UnCorrERR_IntSignal @35 {
       bits 1;
       access ro;
       reset 1'h1;
    }
    field RSVD_DMAC_CHx_INTSIGNAL_ENABLEREG_36to63 @36 {
       bits 28;
       access ro;
       reset 28'hfffffff;
    }
  }
  register CH1_INTCLEARREG @'h98 {
    field Clear_BLOCK_TFR_DONE_IntStat @0 {
       bits 1;
       access wo;
       reset 1'h0;
    }
    field Clear_DMA_TFR_DONE_IntStat @1 {
       bits 1;
       access wo;
       reset 1'h0;
    }
    field RSVD_DMAC_CHx_INTCLEARREG_2 @2 {
       bits 1;
       access wo;
       reset 1'h0;
    }
    field Clear_SRC_TRANSCOMP_IntStat @3 {
       bits 1;
       access wo;
       reset 1'h0;
    }
    field Clear_DST_TRANSCOMP_IntStat @4 {
       bits 1;
       access wo;
       reset 1'h0;
    }
    field Clear_SRC_DEC_ERR_IntStat @5 {
       bits 1;
       access wo;
       reset 1'h0;
    }
    field Clear_DST_DEC_ERR_IntStat @6 {
       bits 1;
       access wo;
       reset 1'h0;
    }
    field Clear_SRC_SLV_ERR_IntStat @7 {
       bits 1;
       access wo;
       reset 1'h0;
    }
    field Clear_DST_SLV_ERR_IntStat @8 {
       bits 1;
       access wo;
       reset 1'h0;
    }
    field Clear_LLI_RD_DEC_ERR_IntStat @9 {
       bits 1;
       access wo;
       reset 1'h0;
    }
    field Clear_LLI_WR_DEC_ERR_IntStat @10 {
       bits 1;
       access wo;
       reset 1'h0;
    }
    field Clear_LLI_RD_SLV_ERR_IntStat @11 {
       bits 1;
       access wo;
       reset 1'h0;
    }
    field Clear_LLI_WR_SLV_ERR_IntStat @12 {
       bits 1;
       access wo;
       reset 1'h0;
    }
    field Clear_SHADOWREG_OR_LLI_INVALID_ERR_IntStat @13 {
       bits 1;
       access wo;
       reset 1'h0;
    }
    field Clear_SLVIF_MULTIBLKTYPE_ERR_IntStat @14 {
       bits 1;
       access wo;
       reset 1'h0;
    }
    field RSVD_DMAC_CHx_INTCLEARREG_15 @15 {
       bits 1;
       access wo;
       reset 1'h0;
    }
    field Clear_SLVIF_DEC_ERR_IntStat @16 {
       bits 1;
       access wo;
       reset 1'h0;
    }
    field Clear_SLVIF_WR2RO_ERR_IntStat @17 {
       bits 1;
       access wo;
       reset 1'h0;
    }
    field Clear_SLVIF_RD2RWO_ERR_IntStat @18 {
       bits 1;
       access wo;
       reset 1'h0;
    }
    field Clear_SLVIF_WRONCHEN_ERR_IntStat @19 {
       bits 1;
       access wo;
       reset 1'h0;
    }
    field Clear_SLVIF_SHADOWREG_WRON_VALID_ERR_IntStat @20 {
       bits 1;
       access wo;
       reset 1'h0;
    }
    field Clear_SLVIF_WRONHOLD_ERR_IntStat @21 {
       bits 1;
       access wo;
       reset 1'h0;
    }
    field RSVD_DMAC_CHx_INTCLEARREG_22to23 @22 {
       bits 2;
       access wo;
       reset 2'h0;
    }
    field Clear_SLVIF_ADDRPARITY_ERR_IntStat @24 {
       bits 1;
       access wo;
       reset 1'h0;
    }
    field Clear_SLVIF_WRPARITY_ERR_IntStat @25 {
       bits 1;
       access wo;
       reset 1'h0;
    }
    field RSVD_DMAC_CHx_INTCLEARREG_26 @26 {
       bits 1;
       access wo;
       reset 1'h0;
    }
    field Clear_CH_LOCK_CLEARED_IntStat @27 {
       bits 1;
       access wo;
       reset 1'h0;
    }
    field Clear_CH_SRC_SUSPENDED_IntStat @28 {
       bits 1;
       access wo;
       reset 1'h0;
    }
    field Clear_CH_SUSPENDED_IntStat @29 {
       bits 1;
       access wo;
       reset 1'h0;
    }
    field Clear_CH_DISABLED_IntStat @30 {
       bits 1;
       access wo;
       reset 1'h0;
    }
    field Clear_CH_ABORTED_IntStat @31 {
       bits 1;
       access wo;
       reset 1'h0;
    }
    field Clear_ECC_PROT_CHMem_CorrERR_IntStat @32 {
       bits 1;
       access wo;
       reset 1'h0;
    }
    field Clear_ECC_PROT_CHMem_UnCorrERR_IntStat @33 {
       bits 1;
       access wo;
       reset 1'h0;
    }
    field Clear_ECC_PROT_UIDMem_CorrERR_IntStat @34 {
       bits 1;
       access wo;
       reset 1'h0;
    }
    field Clear_ECC_PROT_UIDMem_UnCorrERR_IntStat @35 {
       bits 1;
       access wo;
       reset 1'h0;
    }
    field RSVD_DMAC_CHx_INTCLEARREG_36to63 @36 {
       bits 28;
       access wo;
       reset 28'h0;
    }
    attributes { NO_REG_TESTS 1 }
  }
  register CH1_CFG_EXTD @'ha0 {
    field LLI_AXPROT @0 {
       bits 3;
       access rw;
       reset 3'h0;
    }
    field LLI_AXCACHE @3 {
       bits 4;
       access rw;
       reset 4'h0;
    }
    field RSVD_DMAC_CHx_CFG_EXTD_7to63 @7 {
       bits 57;
       access ro;
       reset 57'h0;
    }
  }
}
block apu_DW_axi_dmac_mem_map_Channel2_Registers_Address_Block {
  endian little;
  bytes 8;
  register CH2_SAR @'h0 {
    field SAR @0 {
       bits 64;
       access rw;
       reset 64'h0;
      volatile 1;
    }
  }
  register CH2_DAR @'h8 {
    field DAR @0 {
       bits 64;
       access rw;
       reset 64'h0;
      volatile 1;
    }
  }
  register CH2_BLOCK_TS @'h10 {
    field BLOCK_TS @0 {
       bits 22;
       access rw;
       reset 22'h0;
      volatile 1;
    }
    field RSVD_DMAC_CHx_BLOCK_TSREG_63to22 @22 {
       bits 42;
       access ro;
       reset 42'h0;
      volatile 1;
    }
  }
  register CH2_CTL @'h18 {
    field SMS @0 {
       bits 1;
       access ro;
       reset 1'h0;
    }
    field RSVD_DMAC_CHx_CTL_1 @1 {
       bits 1;
       access ro;
       reset 1'h0;
    }
    field DMS @2 {
       bits 1;
       access ro;
       reset 1'h0;
    }
    field RSVD_DMAC_CHx_CTL_3 @3 {
       bits 1;
       access ro;
       reset 1'h0;
    }
    field SINC @4 {
       bits 1;
       access rw;
       reset 1'h0;
    }
    field RSVD_DMAC_CHx_CTL_5 @5 {
       bits 1;
       access ro;
       reset 1'h0;
    }
    field DINC @6 {
       bits 1;
       access rw;
       reset 1'h0;
    }
    field CRC_EN @7 {
       bits 1;
       access ro;
       reset 1'h0;
    }
    field SRC_TR_WIDTH @8 {
       bits 3;
       access rw;
       reset 3'h2;
    }
    field DST_TR_WIDTH @11 {
       bits 3;
       access rw;
       reset 3'h2;
    }
    field SRC_MSIZE @14 {
       bits 4;
       access rw;
       reset 4'h0;
    }
    field DST_MSIZE @18 {
       bits 4;
       access rw;
       reset 4'h0;
    }
    field AR_CACHE @22 {
       bits 4;
       access rw;
       reset 4'h0;
    }
    field AW_CACHE @26 {
       bits 4;
       access rw;
       reset 4'h0;
    }
    field NonPosted_LastWrite_En @30 {
       bits 1;
       access rw;
       reset 1'h0;
    }
    field RSVD_DMAC_CHx_CTL_31 @31 {
       bits 1;
       access ro;
       reset 1'h0;
    }
    field AR_PROT @32 {
       bits 3;
       access rw;
       reset 3'h0;
    }
    field AW_PROT @35 {
       bits 3;
       access rw;
       reset 3'h0;
    }
    field ARLEN_EN @38 {
       bits 1;
       access rw;
       reset 1'h0;
    }
    field ARLEN @39 {
       bits 8;
       access rw;
       reset 8'h0;
    }
    field AWLEN_EN @47 {
       bits 1;
       access rw;
       reset 1'h0;
    }
    field AWLEN @48 {
       bits 8;
       access rw;
       reset 8'h0;
    }
    field SRC_STAT_EN @56 {
       bits 1;
       access ro;
       reset 1'h0;
    }
    field DST_STAT_EN @57 {
       bits 1;
       access ro;
       reset 1'h0;
    }
    field IOC_BlkTfr @58 {
       bits 1;
       access rw;
       reset 1'h0;
    }
    field RSVD_DMAC_CHx_CTL_59to61 @59 {
       bits 3;
       access ro;
       reset 3'h0;
    }
    field SHADOWREG_OR_LLI_LAST @62 {
       bits 1;
       access rw;
       reset 1'h0;
      volatile 1;
    }
    field SHADOWREG_OR_LLI_VALID @63 {
       bits 1;
       access rw;
       reset 1'h0;
      volatile 1;
    }
    attributes { NO_REG_BIT_BASH_TEST 1 }
  }
  register CH2_CFG @'h20 {
    field SRC_MULTBLK_TYPE @0 {
       bits 2;
       access rw;
       reset 2'h0;
      volatile 1;
    }
    field DST_MULTBLK_TYPE @2 {
       bits 2;
       access rw;
       reset 2'h0;
      volatile 1;
    }
    field RSVD_DMAC_CHx_CFG_4to16 @4 {
       bits 13;
       access ro;
       reset 13'h0;
      volatile 1;
    }
    field LLI_AUTO_RESUME_REQ_EN @17 {
       bits 1;
       access ro;
       reset 1'h0;
      volatile 1;
    }
    field RD_UID @18 {
       bits 3;
       access ro;
       reset 3'h0;
      volatile 1;
    }
    field RSVD_DMAC_CHx_CFG_21to24 @21 {
       bits 4;
       access ro;
       reset 4'h0;
      volatile 1;
    }
    field WR_UID @25 {
       bits 3;
       access ro;
       reset 3'h0;
      volatile 1;
    }
    field RSVD_DMAC_CHx_CFG_28to31 @28 {
       bits 4;
       access ro;
       reset 4'h0;
      volatile 1;
    }
    field TT_FC @32 {
       bits 3;
       access ro;
       reset 3'h0;
      volatile 1;
    }
    field HS_SEL_SRC @35 {
       bits 1;
       access rw;
       reset 1'h1;
      volatile 1;
    }
    field HS_SEL_DST @36 {
       bits 1;
       access rw;
       reset 1'h1;
      volatile 1;
    }
    field SRC_HWHS_POL @37 {
       bits 1;
       access ro;
       reset 1'h0;
      volatile 1;
    }
    field DST_HWHS_POL @38 {
       bits 1;
       access ro;
       reset 1'h0;
      volatile 1;
    }
    field SRC_PER @39 {
       bits 1;
       access ro;
       reset 1'h0;
      volatile 1;
    }
    field RSVD_DMAC_CHx_CFG_42_39 @40 {
       bits 3;
       access ro;
       reset 3'h0;
      volatile 1;
    }
    field RSVD_DMAC_CHx_CFG_43 @43 {
       bits 1;
       access ro;
       reset 1'h0;
      volatile 1;
    }
    field DST_PER @44 {
       bits 1;
       access ro;
       reset 1'h0;
      volatile 1;
    }
    field RSVD_DMAC_CHx_CFG_47_44 @45 {
       bits 3;
       access ro;
       reset 3'h0;
      volatile 1;
    }
    field RSVD_DMAC_CHx_CFG_48 @48 {
       bits 1;
       access ro;
       reset 1'h0;
      volatile 1;
    }
    field CH_PRIOR @49 {
       bits 3;
       access rw;
       reset 3'h0;
      volatile 1;
    }
    field LOCK_CH @52 {
       bits 1;
       access ro;
       reset 1'h0;
      volatile 1;
    }
    field LOCK_CH_L @53 {
       bits 2;
       access ro;
       reset 2'h0;
      volatile 1;
    }
    field SRC_OSR_LMT @55 {
       bits 4;
       access rw;
       reset 4'h0;
      volatile 1;
    }
    field DST_OSR_LMT @59 {
       bits 4;
       access rw;
       reset 4'h0;
      volatile 1;
    }
    field RSVD_DMAC_CHx_CFG_63 @63 {
       bits 1;
       access ro;
       reset 1'h0;
      volatile 1;
    }
  }
  register CH2_LLP @'h28 {
    field LMS @0 {
       bits 1;
       access ro;
       reset 1'h0;
      volatile 1;
    }
    field RSVD_DMAC_CHx_LLP_1to5 @1 {
       bits 5;
       access ro;
       reset 5'h0;
      volatile 1;
    }
    field LOC @6 {
       bits 58;
       access rw;
       reset 58'h0;
      volatile 1;
    }
  }
  register CH2_STATUSREG @'h30 {
    field CMPLTD_BLK_TFR_SIZE @0 {
       bits 22;
       access ro;
       reset 22'h0;
      volatile 1;
    }
    field RSVD_DMAC_CHx_STATUSREG_22to31 @22 {
       bits 10;
       access ro;
       reset 10'h0;
      volatile 1;
    }
    field DATA_LEFT_IN_FIFO @32 {
       bits 15;
       access ro;
       reset 15'h0;
      volatile 1;
    }
    field RSVD_DMAC_CHx_STATUSREG_47to63 @47 {
       bits 17;
       access ro;
       reset 17'h0;
      volatile 1;
    }
    attributes { NO_REG_BIT_BASH_TEST 1 }
  }
  register CH2_SWHSSRCREG @'h38 {
    field SWHS_REQ_SRC @0 {
       bits 1;
       access rw;
       reset 1'h0;
      volatile 1;
    }
    field SWHS_REQ_SRC_WE @1 {
       bits 1;
       access wo;
       reset 1'h0;
      volatile 1;
    }
    field SWHS_SGLREQ_SRC @2 {
       bits 1;
       access rw;
       reset 1'h0;
      volatile 1;
    }
    field SWHS_SGLREQ_SRC_WE @3 {
       bits 1;
       access wo;
       reset 1'h0;
      volatile 1;
    }
    field SWHS_LST_SRC @4 {
       bits 1;
       access rw;
       reset 1'h0;
      volatile 1;
    }
    field SWHS_LST_SRC_WE @5 {
       bits 1;
       access wo;
       reset 1'h0;
      volatile 1;
    }
    field RSVD_DMAC_CHx_SWHSSRCREG_6to63 @6 {
       bits 58;
       access ro;
       reset 58'h0;
      volatile 1;
    }
  }
  register CH2_SWHSDSTREG @'h40 {
    field SWHS_REQ_DST @0 {
       bits 1;
       access rw;
       reset 1'h0;
      volatile 1;
    }
    field SWHS_REQ_DST_WE @1 {
       bits 1;
       access wo;
       reset 1'h0;
      volatile 1;
    }
    field SWHS_SGLREQ_DST @2 {
       bits 1;
       access rw;
       reset 1'h0;
      volatile 1;
    }
    field SWHS_SGLREQ_DST_WE @3 {
       bits 1;
       access wo;
       reset 1'h0;
      volatile 1;
    }
    field SWHS_LST_DST @4 {
       bits 1;
       access rw;
       reset 1'h0;
      volatile 1;
    }
    field SWHS_LST_DST_WE @5 {
       bits 1;
       access wo;
       reset 1'h0;
      volatile 1;
    }
    field RSVD_DMAC_CHx_SWHSDSTREG_6to63 @6 {
       bits 58;
       access ro;
       reset 58'h0;
      volatile 1;
    }
  }
  register CH2_BLK_TFR_RESUMEREQREG @'h48 {
    field BLK_TFR_RESUMEREQ @0 {
       bits 1;
       access wo;
       reset 1'h0;
    }
    field RSVD_DMAC_CHx_BLK_TFR_RESUMEREQREG_1to63 @1 {
       bits 63;
       access wo;
       reset 63'h0;
    }
    attributes { NO_REG_TESTS 1 }
  }
  register CH2_AXI_IDREG @'h50 {
    field AXI_READ_ID_SUFFIX @0 {
       bits 6;
       access rw;
       reset 6'h0;
    }
    field RSVD_DMAC_CHx_AXI_IDREG_IDW_L2NCm1to31 @6 {
       bits 10;
       access ro;
       reset 10'h0;
    }
    field AXI_WRITE_ID_SUFFIX @16 {
       bits 6;
       access rw;
       reset 6'h0;
    }
    field RSVD_DMAC_CHx_AXI_IDREG_IDW_L2NCm32to63 @22 {
       bits 10;
       access ro;
       reset 10'h0;
    }
    field RSVD_DMAC_CHx_AXI_IDREG_32to63 @32 {
       bits 32;
       access ro;
       reset 32'h0;
    }
  }
  register CH2_AXI_QOSREG @'h58 {
    field AXI_AWQOS @0 {
       bits 4;
       access ro;
       reset 4'h0;
    }
    field AXI_ARQOS @4 {
       bits 4;
       access ro;
       reset 4'h0;
    }
    field RSVD_DMAC_CHx_AXI_QOSREG_8to63 @8 {
       bits 56;
       access ro;
       reset 56'h0;
    }
    attributes { NO_REG_BIT_BASH_TEST 1 }
  }
  register CH2_INTSTATUS_ENABLEREG @'h80 {
    field Enable_BLOCK_TFR_DONE_IntStat @0 {
       bits 1;
       access rw;
       reset 1'h1;
    }
    field Enable_DMA_TFR_DONE_IntStat @1 {
       bits 1;
       access rw;
       reset 1'h1;
    }
    field RSVD_DMAC_CHx_INTSTATUS_ENABLEREG_2 @2 {
       bits 1;
       access ro;
       reset 1'h1;
    }
    field Enable_SRC_TRANSCOMP_IntStat @3 {
       bits 1;
       access rw;
       reset 1'h1;
    }
    field Enable_DST_TRANSCOMP_IntStat @4 {
       bits 1;
       access rw;
       reset 1'h1;
    }
    field Enable_SRC_DEC_ERR_IntStat @5 {
       bits 1;
       access rw;
       reset 1'h1;
    }
    field Enable_DST_DEC_ERR_IntStat @6 {
       bits 1;
       access rw;
       reset 1'h1;
    }
    field Enable_SRC_SLV_ERR_IntStat @7 {
       bits 1;
       access rw;
       reset 1'h1;
    }
    field Enable_DST_SLV_ERR_IntStat @8 {
       bits 1;
       access rw;
       reset 1'h1;
    }
    field Enable_LLI_RD_DEC_ERR_IntStat @9 {
       bits 1;
       access rw;
       reset 1'h1;
    }
    field Enable_LLI_WR_DEC_ERR_IntStat @10 {
       bits 1;
       access rw;
       reset 1'h1;
    }
    field Enable_LLI_RD_SLV_ERR_IntStat @11 {
       bits 1;
       access rw;
       reset 1'h1;
    }
    field Enable_LLI_WR_SLV_ERR_IntStat @12 {
       bits 1;
       access rw;
       reset 1'h1;
    }
    field Enable_SHADOWREG_OR_LLI_INVALID_ERR_IntStat @13 {
       bits 1;
       access rw;
       reset 1'h1;
    }
    field Enable_SLVIF_MULTIBLKTYPE_ERR_IntStat @14 {
       bits 1;
       access rw;
       reset 1'h1;
    }
    field RSVD_DMAC_CHx_INTSTATUS_ENABLEREG_15 @15 {
       bits 1;
       access ro;
       reset 1'h1;
    }
    field Enable_SLVIF_DEC_ERR_IntStat @16 {
       bits 1;
       access rw;
       reset 1'h1;
    }
    field Enable_SLVIF_WR2RO_ERR_IntStat @17 {
       bits 1;
       access rw;
       reset 1'h1;
    }
    field Enable_SLVIF_RD2RWO_ERR_IntStat @18 {
       bits 1;
       access rw;
       reset 1'h1;
    }
    field Enable_SLVIF_WRONCHEN_ERR_IntStat @19 {
       bits 1;
       access rw;
       reset 1'h1;
    }
    field Enable_SLVIF_SHADOWREG_WRON_VALID_ERR_IntStat @20 {
       bits 1;
       access rw;
       reset 1'h1;
    }
    field Enable_SLVIF_WRONHOLD_ERR_IntStat @21 {
       bits 1;
       access rw;
       reset 1'h1;
    }
    field RSVD_DMAC_CHx_INTSTATUS_ENABLEREG_22to23 @22 {
       bits 2;
       access ro;
       reset 2'h3;
    }
    field Enable_SLVIF_ADDRPARITY_ERR_IntStat @24 {
       bits 1;
       access ro;
       reset 1'h1;
    }
    field Enable_SLVIF_WRPARITY_ERR_IntStat @25 {
       bits 1;
       access ro;
       reset 1'h1;
    }
    field RSVD_DMAC_CHx_INTSTATUS_ENABLEREG_26 @26 {
       bits 1;
       access ro;
       reset 1'h1;
    }
    field Enable_CH_LOCK_CLEARED_IntStat @27 {
       bits 1;
       access rw;
       reset 1'h1;
    }
    field Enable_CH_SRC_SUSPENDED_IntStat @28 {
       bits 1;
       access rw;
       reset 1'h1;
    }
    field Enable_CH_SUSPENDED_IntStat @29 {
       bits 1;
       access rw;
       reset 1'h1;
    }
    field Enable_CH_DISABLED_IntStat @30 {
       bits 1;
       access rw;
       reset 1'h1;
    }
    field Enable_CH_ABORTED_IntStat @31 {
       bits 1;
       access rw;
       reset 1'h1;
    }
    field Enable_ECC_PROT_CHMem_CorrERR_IntStat @32 {
       bits 1;
       access ro;
       reset 1'h1;
    }
    field Enable_ECC_PROT_CHMem_UnCorrERR_IntStat @33 {
       bits 1;
       access ro;
       reset 1'h1;
    }
    field Enable_ECC_PROT_UIDMem_CorrERR_IntStat @34 {
       bits 1;
       access ro;
       reset 1'h1;
    }
    field Enable_ECC_PROT_UIDMem_UnCorrERR_IntStat @35 {
       bits 1;
       access ro;
       reset 1'h1;
    }
    field RSVD_DMAC_CHx_INTSTATUS_ENABLEREG_32to63 @36 {
       bits 28;
       access ro;
       reset 28'hfffffff;
    }
  }
  register CH2_INTSTATUS @'h88 {
    field BLOCK_TFR_DONE_IntStat @0 {
       bits 1;
       access ro;
       reset 1'h0;
      volatile 1;
    }
    field DMA_TFR_DONE_IntStat @1 {
       bits 1;
       access ro;
       reset 1'h0;
      volatile 1;
    }
    field RSVD_DMAC_CHx_INTSTATUSREG_2 @2 {
       bits 1;
       access ro;
       reset 1'h0;
      volatile 1;
    }
    field SRC_TRANSCOMP_IntStat @3 {
       bits 1;
       access ro;
       reset 1'h0;
      volatile 1;
    }
    field DST_TRANSCOMP_IntStat @4 {
       bits 1;
       access ro;
       reset 1'h0;
      volatile 1;
    }
    field SRC_DEC_ERR_IntStat @5 {
       bits 1;
       access ro;
       reset 1'h0;
      volatile 1;
    }
    field DST_DEC_ERR_IntStat @6 {
       bits 1;
       access ro;
       reset 1'h0;
      volatile 1;
    }
    field SRC_SLV_ERR_IntStat @7 {
       bits 1;
       access ro;
       reset 1'h0;
      volatile 1;
    }
    field DST_SLV_ERR_IntStat @8 {
       bits 1;
       access ro;
       reset 1'h0;
      volatile 1;
    }
    field LLI_RD_DEC_ERR_IntStat @9 {
       bits 1;
       access ro;
       reset 1'h0;
      volatile 1;
    }
    field LLI_WR_DEC_ERR_IntStat @10 {
       bits 1;
       access ro;
       reset 1'h0;
      volatile 1;
    }
    field LLI_RD_SLV_ERR_IntStat @11 {
       bits 1;
       access ro;
       reset 1'h0;
      volatile 1;
    }
    field LLI_WR_SLV_ERR_IntStat @12 {
       bits 1;
       access ro;
       reset 1'h0;
      volatile 1;
    }
    field SHADOWREG_OR_LLI_INVALID_ERR_IntStat @13 {
       bits 1;
       access ro;
       reset 1'h0;
      volatile 1;
    }
    field SLVIF_MULTIBLKTYPE_ERR_IntStat @14 {
       bits 1;
       access ro;
       reset 1'h0;
      volatile 1;
    }
    field RSVD_DMAC_CHx_INTSTATUSREG_15 @15 {
       bits 1;
       access ro;
       reset 1'h0;
      volatile 1;
    }
    field SLVIF_DEC_ERR_IntStat @16 {
       bits 1;
       access ro;
       reset 1'h0;
      volatile 1;
    }
    field SLVIF_WR2RO_ERR_IntStat @17 {
       bits 1;
       access ro;
       reset 1'h0;
      volatile 1;
    }
    field SLVIF_RD2RWO_ERR_IntStat @18 {
       bits 1;
       access ro;
       reset 1'h0;
      volatile 1;
    }
    field SLVIF_WRONCHEN_ERR_IntStat @19 {
       bits 1;
       access ro;
       reset 1'h0;
      volatile 1;
    }
    field SLVIF_SHADOWREG_WRON_VALID_ERR_IntStat @20 {
       bits 1;
       access ro;
       reset 1'h0;
      volatile 1;
    }
    field SLVIF_WRONHOLD_ERR_IntStat @21 {
       bits 1;
       access ro;
       reset 1'h0;
      volatile 1;
    }
    field RSVD_DMAC_CHx_INTSTATUSREG_22to23 @22 {
       bits 2;
       access ro;
       reset 2'h0;
      volatile 1;
    }
    field SLVIF_ADDRPARITY_ERR_IntStat @24 {
       bits 1;
       access ro;
       reset 1'h0;
      volatile 1;
    }
    field SLVIF_WRPARITY_ERR_IntStat @25 {
       bits 1;
       access ro;
       reset 1'h0;
      volatile 1;
    }
    field RSVD_DMAC_CHx_INTSTATUSREG_26 @26 {
       bits 1;
       access ro;
       reset 1'h0;
      volatile 1;
    }
    field CH_LOCK_CLEARED_IntStat @27 {
       bits 1;
       access ro;
       reset 1'h0;
      volatile 1;
    }
    field CH_SRC_SUSPENDED_IntStat @28 {
       bits 1;
       access ro;
       reset 1'h0;
      volatile 1;
    }
    field CH_SUSPENDED_IntStat @29 {
       bits 1;
       access ro;
       reset 1'h0;
      volatile 1;
    }
    field CH_DISABLED_IntStat @30 {
       bits 1;
       access ro;
       reset 1'h0;
      volatile 1;
    }
    field CH_ABORTED_IntStat @31 {
       bits 1;
       access ro;
       reset 1'h0;
      volatile 1;
    }
    field ECC_PROT_CHMem_CorrERR_IntStat @32 {
       bits 1;
       access ro;
       reset 1'h0;
      volatile 1;
    }
    field ECC_PROT_CHMem_UnCorrERR_IntStat @33 {
       bits 1;
       access ro;
       reset 1'h0;
      volatile 1;
    }
    field ECC_PROT_UIDMem_CorrERR_IntStat @34 {
       bits 1;
       access ro;
       reset 1'h0;
      volatile 1;
    }
    field ECC_PROT_UIDMem_UnCorrERR_IntStat @35 {
       bits 1;
       access ro;
       reset 1'h0;
      volatile 1;
    }
    field RSVD_DMAC_CHx_INTSTATUSREG_36to63 @36 {
       bits 28;
       access ro;
       reset 28'h0;
      volatile 1;
    }
    attributes { NO_REG_BIT_BASH_TEST 1 }
  }
  register CH2_INTSIGNAL_ENABLEREG @'h90 {
    field Enable_BLOCK_TFR_DONE_IntSignal @0 {
       bits 1;
       access rw;
       reset 1'h1;
    }
    field Enable_DMA_TFR_DONE_IntSignal @1 {
       bits 1;
       access rw;
       reset 1'h1;
    }
    field RSVD_DMAC_CHx_INTSTATUS_ENABLEREG_2 @2 {
       bits 1;
       access ro;
       reset 1'h1;
    }
    field Enable_SRC_TRANSCOMP_IntSignal @3 {
       bits 1;
       access rw;
       reset 1'h1;
    }
    field Enable_DST_TRANSCOMP_IntSignal @4 {
       bits 1;
       access rw;
       reset 1'h1;
    }
    field Enable_SRC_DEC_ERR_IntSignal @5 {
       bits 1;
       access rw;
       reset 1'h1;
    }
    field Enable_DST_DEC_ERR_IntSignal @6 {
       bits 1;
       access rw;
       reset 1'h1;
    }
    field Enable_SRC_SLV_ERR_IntSignal @7 {
       bits 1;
       access rw;
       reset 1'h1;
    }
    field Enable_DST_SLV_ERR_IntSignal @8 {
       bits 1;
       access rw;
       reset 1'h1;
    }
    field Enable_LLI_RD_DEC_ERR_IntSignal @9 {
       bits 1;
       access rw;
       reset 1'h1;
    }
    field Enable_LLI_WR_DEC_ERR_IntSignal @10 {
       bits 1;
       access rw;
       reset 1'h1;
    }
    field Enable_LLI_RD_SLV_ERR_IntSignal @11 {
       bits 1;
       access rw;
       reset 1'h1;
    }
    field Enable_LLI_WR_SLV_ERR_IntSignal @12 {
       bits 1;
       access rw;
       reset 1'h1;
    }
    field Enable_SHADOWREG_OR_LLI_INVALID_ERR_IntSignal @13 {
       bits 1;
       access rw;
       reset 1'h1;
    }
    field Enable_SLVIF_MULTIBLKTYPE_ERR_IntSignal @14 {
       bits 1;
       access rw;
       reset 1'h1;
    }
    field RSVD_DMAC_CHx_INTSTATUS_ENABLEREG_15 @15 {
       bits 1;
       access ro;
       reset 1'h1;
    }
    field Enable_SLVIF_DEC_ERR_IntSignal @16 {
       bits 1;
       access rw;
       reset 1'h1;
    }
    field Enable_SLVIF_WR2RO_ERR_IntSignal @17 {
       bits 1;
       access rw;
       reset 1'h1;
    }
    field Enable_SLVIF_RD2RWO_ERR_IntSignal @18 {
       bits 1;
       access rw;
       reset 1'h1;
    }
    field Enable_SLVIF_WRONCHEN_ERR_IntSignal @19 {
       bits 1;
       access rw;
       reset 1'h1;
    }
    field Enable_SLVIF_SHADOWREG_WRON_VALID_ERR_IntSignal @20 {
       bits 1;
       access rw;
       reset 1'h1;
    }
    field Enable_SLVIF_WRONHOLD_ERR_IntSignal @21 {
       bits 1;
       access rw;
       reset 1'h1;
    }
    field RSVD_DMAC_CHx_INTSIGNAL_ENABLEREG_22to23 @22 {
       bits 2;
       access ro;
       reset 2'h3;
    }
    field Enable_SLVIF_ADDRPARITY_ERR_IntSignal @24 {
       bits 1;
       access ro;
       reset 1'h1;
    }
    field Enable_SLVIF_WRPARITY_ERR_IntSignal @25 {
       bits 1;
       access ro;
       reset 1'h1;
    }
    field RSVD_DMAC_CHx_INTSIGNAL_ENABLEREG_26 @26 {
       bits 1;
       access ro;
       reset 1'h1;
    }
    field Enable_CH_LOCK_CLEARED_IntSignal @27 {
       bits 1;
       access rw;
       reset 1'h1;
    }
    field Enable_CH_SRC_SUSPENDED_IntSignal @28 {
       bits 1;
       access rw;
       reset 1'h1;
    }
    field Enable_CH_SUSPENDED_IntSignal @29 {
       bits 1;
       access rw;
       reset 1'h1;
    }
    field Enable_CH_DISABLED_IntSignal @30 {
       bits 1;
       access rw;
       reset 1'h1;
    }
    field Enable_CH_ABORTED_IntSignal @31 {
       bits 1;
       access rw;
       reset 1'h1;
    }
    field Enable_ECC_PROT_CHMem_CorrERR_IntSignal @32 {
       bits 1;
       access ro;
       reset 1'h1;
    }
    field Enable_ECC_PROT_CHMem_UnCorrERR_IntSignal @33 {
       bits 1;
       access ro;
       reset 1'h1;
    }
    field Enable_ECC_PROT_UIDMem_CorrERR_IntSignal @34 {
       bits 1;
       access ro;
       reset 1'h1;
    }
    field Enable_ECC_PROT_UIDMem_UnCorrERR_IntSignal @35 {
       bits 1;
       access ro;
       reset 1'h1;
    }
    field RSVD_DMAC_CHx_INTSIGNAL_ENABLEREG_36to63 @36 {
       bits 28;
       access ro;
       reset 28'hfffffff;
    }
  }
  register CH2_INTCLEARREG @'h98 {
    field Clear_BLOCK_TFR_DONE_IntStat @0 {
       bits 1;
       access wo;
       reset 1'h0;
    }
    field Clear_DMA_TFR_DONE_IntStat @1 {
       bits 1;
       access wo;
       reset 1'h0;
    }
    field RSVD_DMAC_CHx_INTCLEARREG_2 @2 {
       bits 1;
       access wo;
       reset 1'h0;
    }
    field Clear_SRC_TRANSCOMP_IntStat @3 {
       bits 1;
       access wo;
       reset 1'h0;
    }
    field Clear_DST_TRANSCOMP_IntStat @4 {
       bits 1;
       access wo;
       reset 1'h0;
    }
    field Clear_SRC_DEC_ERR_IntStat @5 {
       bits 1;
       access wo;
       reset 1'h0;
    }
    field Clear_DST_DEC_ERR_IntStat @6 {
       bits 1;
       access wo;
       reset 1'h0;
    }
    field Clear_SRC_SLV_ERR_IntStat @7 {
       bits 1;
       access wo;
       reset 1'h0;
    }
    field Clear_DST_SLV_ERR_IntStat @8 {
       bits 1;
       access wo;
       reset 1'h0;
    }
    field Clear_LLI_RD_DEC_ERR_IntStat @9 {
       bits 1;
       access wo;
       reset 1'h0;
    }
    field Clear_LLI_WR_DEC_ERR_IntStat @10 {
       bits 1;
       access wo;
       reset 1'h0;
    }
    field Clear_LLI_RD_SLV_ERR_IntStat @11 {
       bits 1;
       access wo;
       reset 1'h0;
    }
    field Clear_LLI_WR_SLV_ERR_IntStat @12 {
       bits 1;
       access wo;
       reset 1'h0;
    }
    field Clear_SHADOWREG_OR_LLI_INVALID_ERR_IntStat @13 {
       bits 1;
       access wo;
       reset 1'h0;
    }
    field Clear_SLVIF_MULTIBLKTYPE_ERR_IntStat @14 {
       bits 1;
       access wo;
       reset 1'h0;
    }
    field RSVD_DMAC_CHx_INTCLEARREG_15 @15 {
       bits 1;
       access wo;
       reset 1'h0;
    }
    field Clear_SLVIF_DEC_ERR_IntStat @16 {
       bits 1;
       access wo;
       reset 1'h0;
    }
    field Clear_SLVIF_WR2RO_ERR_IntStat @17 {
       bits 1;
       access wo;
       reset 1'h0;
    }
    field Clear_SLVIF_RD2RWO_ERR_IntStat @18 {
       bits 1;
       access wo;
       reset 1'h0;
    }
    field Clear_SLVIF_WRONCHEN_ERR_IntStat @19 {
       bits 1;
       access wo;
       reset 1'h0;
    }
    field Clear_SLVIF_SHADOWREG_WRON_VALID_ERR_IntStat @20 {
       bits 1;
       access wo;
       reset 1'h0;
    }
    field Clear_SLVIF_WRONHOLD_ERR_IntStat @21 {
       bits 1;
       access wo;
       reset 1'h0;
    }
    field RSVD_DMAC_CHx_INTCLEARREG_22to23 @22 {
       bits 2;
       access wo;
       reset 2'h0;
    }
    field Clear_SLVIF_ADDRPARITY_ERR_IntStat @24 {
       bits 1;
       access wo;
       reset 1'h0;
    }
    field Clear_SLVIF_WRPARITY_ERR_IntStat @25 {
       bits 1;
       access wo;
       reset 1'h0;
    }
    field RSVD_DMAC_CHx_INTCLEARREG_26 @26 {
       bits 1;
       access wo;
       reset 1'h0;
    }
    field Clear_CH_LOCK_CLEARED_IntStat @27 {
       bits 1;
       access wo;
       reset 1'h0;
    }
    field Clear_CH_SRC_SUSPENDED_IntStat @28 {
       bits 1;
       access wo;
       reset 1'h0;
    }
    field Clear_CH_SUSPENDED_IntStat @29 {
       bits 1;
       access wo;
       reset 1'h0;
    }
    field Clear_CH_DISABLED_IntStat @30 {
       bits 1;
       access wo;
       reset 1'h0;
    }
    field Clear_CH_ABORTED_IntStat @31 {
       bits 1;
       access wo;
       reset 1'h0;
    }
    field Clear_ECC_PROT_CHMem_CorrERR_IntStat @32 {
       bits 1;
       access wo;
       reset 1'h0;
    }
    field Clear_ECC_PROT_CHMem_UnCorrERR_IntStat @33 {
       bits 1;
       access wo;
       reset 1'h0;
    }
    field Clear_ECC_PROT_UIDMem_CorrERR_IntStat @34 {
       bits 1;
       access wo;
       reset 1'h0;
    }
    field Clear_ECC_PROT_UIDMem_UnCorrERR_IntStat @35 {
       bits 1;
       access wo;
       reset 1'h0;
    }
    field RSVD_DMAC_CHx_INTCLEARREG_36to63 @36 {
       bits 28;
       access wo;
       reset 28'h0;
    }
    attributes { NO_REG_TESTS 1 }
  }
  register CH2_CFG_EXTD @'ha0 {
    field LLI_AXPROT @0 {
       bits 3;
       access rw;
       reset 3'h0;
    }
    field LLI_AXCACHE @3 {
       bits 4;
       access rw;
       reset 4'h0;
    }
    field RSVD_DMAC_CHx_CFG_EXTD_7to63 @7 {
       bits 57;
       access ro;
       reset 57'h0;
    }
  }
}



system apu_DW_axi_dmac {
  bytes 8;
  block apu_DW_axi_dmac_mem_map_Common_Registers_Address_Block @'h0;
  block apu_DW_axi_dmac_mem_map_Channel1_Registers_Address_Block @'h100;
  block apu_DW_axi_dmac_mem_map_Channel2_Registers_Address_Block @'h200;
}

