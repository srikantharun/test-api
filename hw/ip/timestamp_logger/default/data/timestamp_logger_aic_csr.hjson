// Copyright lowRISC contributors.
// Licensed under the Apache License, Version 2.0, see LICENSE for details.
// SPDX-License-Identifier: Apache-2.0
{ name: "timestamp_logger_aic_csr",
  clocking: [{clock: "clk_i", reset: "rst_ni"}],
  bus_interfaces: [
    { protocol: "tlul", direction: "device" }
  ],
  regwidth: "64",
  addrcap: "0x10000",
  param_list : [
    {name:"PLEN", type:"int", default:"40"}
    {name:"AW", type:"int", default:"40"}
    {name:"PC_COMPARES", type:"int", default:"8"}
    {name:"ST_COMPARES", type:"int", default:"4"}
    {name:"LD_COMPARES", type:"int", default:"4"}
  ]
  registers: [
    { skipto: "0x200" },
    { name: "SWEP",
      desc: "Software endpoint.",
      swaccess: "wo",
      hwaccess: "hro",
      hwqe: True
      fields: [
        {
            bits: "1:0",
            name: "swep_message",
            desc: '''
                  Message to be timestamped, any write will trigger.
                  ''',
            resval: 0x0
        }
      ]
    }
    { name: "DP_DEV_MASK",
      desc: "Mask the datapath units from logging",
      swaccess: "rw",
      hwaccess: "hro"
      fields: [
          {
              bits: "0",
              name: "m_ifd0",
              desc: 'When set a ts_start or ts_end of `m_ifd0` will cause a trigger',
              resval: 0x1
          }
          {
              bits: "1",
              name: "m_ifd1",
              desc: 'When set a ts_start or ts_end of `m_ifd1` will cause a trigger',
              resval: 0x1
          }
          {
              bits: "2",
              name: "m_ifd2",
              desc: 'When set a ts_start or ts_end of `m_ifd2` will cause a trigger',
              resval: 0x1
          }
          {
              bits: "3",
              name: "m_ifdw",
              desc: 'When set a ts_start or ts_end of `m_ifdw` will cause a trigger',
              resval: 0x1
          }
          {
              bits: "4",
              name: "d_ifd0",
              desc: 'When set a ts_start or ts_end of `d_ifd0` will cause a trigger',
              resval: 0x1
          }
          {
              bits: "5",
              name: "d_ifd1",
              desc: 'When set a ts_start or ts_end of `d_ifd1` will cause a trigger',
              resval: 0x1
          }
          {
              bits: "6",
              name: "m_odr",
              desc: 'When set a ts_start or ts_end of `m_odr` will cause a trigger',
              resval: 0x1
          }
          {
              bits: "7",
              name: "d_odr",
              desc: 'When set a ts_start or ts_end of `d_odr` will cause a trigger',
              resval: 0x1
          }
          {
              bits: "8",
              name: "mid_mvmexe",
              desc: 'When set a ts_start or ts_end of `mid_mvm_exe` will cause a trigger',
              resval: 0x1
          }
          {
              bits: "9",
              name: "mid_mvmprg",
              desc: 'When set a ts_start or ts_end of `mid_mvm_prg` will cause a trigger',
              resval: 0x1
          }
          {
              bits: "10",
              name: "mid_iau",
              desc: 'When set a ts_start or ts_end of `mid_iau` will cause a trigger',
              resval: 0x1
          }
          {
              bits: "11",
              name: "mid_dpu",
              desc: 'When set a ts_start or ts_end of `mid_dpu` will cause a trigger',
              resval: 0x1
          }
          {
              bits: "12",
              name: "did_dwpu",
              desc: 'When set a ts_start or ts_end of `did_dwpu` will cause a trigger',
              resval: 0x1
          }
          {
              bits: "13",
              name: "did_iau",
              desc: 'When set a ts_start or ts_end of `did_iau` will cause a trigger',
              resval: 0x1
          }
          {
              bits: "14",
              name: "did_dpu",
              desc: 'When set a ts_start or ts_end of `did_dpu` will cause a trigger',
              resval: 0x1
          }
          {
              bits: "15",
              name: "dma_ch0",
              desc: 'When set a ts_start or ts_end of `dma_ch0` will cause a trigger',
              resval: 0x1
          }
          {
              bits: "16",
              name: "dma_ch1",
              desc: 'When set a ts_start or ts_end of `dma_ch1` will cause a trigger',
              resval: 0x1
          }
      ]
    },
    { multireg: {name: "PC_COMPARE"
      desc: "PC Compare value: trigger is set when value matches value",
      count: "PC_COMPARES",
      cname: "pc_value",
      swaccess: "rw",
      hwaccess: "hro",
      fields: [
        {
            bits: "PLEN-2:0",
            name: "pc_value",
            resval: 0,
            desc: '''
            Value to check and create a trigger.
                  '''
        }
      ]
    }},
    { multireg: {name: "ST_TRACE_LOW"
      desc: "Low part of the store check. Trigger is set when `(aw_addr >= ST_TRACE_LOW_{n}) && (aw_addr < ST_TRACE_HIGH_{n})`",
      count: "ST_COMPARES",
      cname: "st_low",
      swaccess: "rw",
      hwaccess: "hro",
      fields: [
        {
            bits: "AW-1:0",
            name: "st_low",
            resval: 0,
            desc: '''
            Low part of the store check.
                  '''
        }
      ]
    }},
    { multireg: {name: "ST_TRACE_HIGH"
      desc: "High part of the store check. Trigger is set when `(aw_addr >= ST_TRACE_LOW_{n}) && (aw_addr < ST_TRACE_HIGH_{n})`",
      count: "ST_COMPARES",
      cname: "st_high",
      swaccess: "rw",
      hwaccess: "hro",
      fields: [
        {
            bits: "AW-1:0",
            name: "st_high",
            resval: 0,
            desc: '''
            High part of the store check.
                  '''
        }
      ]
    }},
    { multireg: {name: "LD_TRACE_LOW"
      desc: "Low part of the load check. Trigger is set when `(ar_addr >= LD_TRACE_LOW_{n}) && (ar_addr < LD_TRACE_HIGH_{n})`",
      count: "LD_COMPARES",
      cname: "ld_low",
      swaccess: "rw",
      hwaccess: "hro",
      fields: [
        {
            bits: "AW-1:0",
            name: "ld_low",
            resval: 0,
            desc: '''
            Low part of the load check.
                  '''
        }
      ]
    }},
    { multireg: {name: "LD_TRACE_HIGH"
      desc: "High part of the load check. Trigger is set when `(ar_addr >= LD_TRACE_LOW_{n}) && (ar_addr < LD_TRACE_HIGH_{n})`",
      count: "LD_COMPARES",
      cname: "ld_high",
      swaccess: "rw",
      hwaccess: "hro",
      fields: [
        {
            bits: "AW-1:0",
            name: "ld_high",
            resval: 0,
            desc: '''
            High part of the load check.
                  '''
        }
      ]
    }}
  ]
}
