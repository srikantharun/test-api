// Copyright lowRISC contributors.
// Licensed under the Apache License, Version 2.0, see LICENSE for details.
// SPDX-License-Identifier: Apache-2.0
{ name: "otp_memory",
  regwidth: "32",
  addrcap: "0x800",
  registers: [
    { window: {
        name: "OTP_MEM"
        items: "512"
        swaccess: "rw",
        desc: '''
        Reads and writes are translated to OTP programming
        '''
      }
    }
  ]
}
