// Copyright lowRISC contributors.
// Licensed under the Apache License, Version 2.0, see LICENSE for details.
// SPDX-License-Identifier: Apache-2.0
{ name: "otp_wrapper_csr",
  clocking: [{clock: "clk_i", reset: "rst_ni"}],
  bus_interfaces: [
    { protocol: "tlul", direction: "device" }
  ],
  regwidth: "32",
  addrcap: "0x2000",
  registers: [
    { window: {
        name: "SW_WINDOW"
        items: "512"
        swaccess: "rw",
        desc: '''
        Reads and writes are translated to OTP programming
        '''
      }
    },
    { skipto: "0x1000" },
    { name: "LOCK",
      desc: "Test outputs.",
      swaccess: "ro",
      hwaccess: "hwo",
      hwext: "true"
      fields: [
        {
            bits: "7:0",
            desc: ''' Test outputs. No specific description found in the OTP datasheet.
            '''
        }
      ]
    },
    { name: "CONTROL",
      desc: '''Control fields for OTP access'''
      swaccess: "rw",
      hwaccess: "hro",
      fields: [
        {
            bits: "0",
            name: "softlock"
            desc: '''OTP is soft locked to prevent accidentaly writes from happening this bit guards any writes to the OTP.”.
            '''
            resval: 0
        }
        {
            bits: "1",
            name: "smart_en"
            desc: '''Smart Programming Enable'''
            resval: 1
        }
      ]
    },
    { name: "STATUS",
      desc: '''OTP logic status'''
      swaccess: "ro",
      hwaccess: "hwo",
      hwext : True
      fields: [
        {
            bits: "0",
            name: "prgm_error"
            desc: '''The OTP encountered a fatal write error. Discard the piece.'''
        }
        {
            bits: "1",
            name: "clear_req"
            desc: '''Decommissioning requested by eSecure.'''
        }
        {
            bits: "2",
            name: "clear_done"
            desc: '''Decommissioning process complete.'''
        }
        {
            bits: "3",
            name: "clear_active"
            desc: '''Decommissioning in progress.'''
        }
      ]
    },
    { name: "tINIT_P0",
      desc: "# clock cycles stay in INIT_P0 state. This represents time between asserting CEB and asserting RSTB. tCSRST = 100us = 5000 cycles @ 50MHz",
      swaccess: "rw",
      hwaccess: "hro",
      fields: [
        {
            bits: "15:0",
            resval: 5000
        }
      ]
    },
    { name: "tINIT_P1",
      desc: "# clock cycles stay in INIT_P1 state. This represents the reset pulse width. tRW = min 1000ns = 50 cycles at 50MHz.",
      swaccess: "rw",
      hwaccess: "hro",
      fields: [
        {
            bits: "15:0",
            resval: 50
        }
      ]
    },
    { name: "tINIT_P2",
      desc: "# clock cycles stay in INIT_P2 state. This represents time from last operation to raising CEB. No time given for this 1us = 50cycles @ 50MHz.",
      swaccess: "rw",
      hwaccess: "hro",
      fields: [
        {
            bits: "15:0",
            resval: 50
        }
      ]
    },
    { name: "tRD_P0",
      desc: "# clock cycles stay in RD_P0 state. This represents the time between deactivation of RSTB / new address application and activation of READEN. max(tRSTS, tAS) = 20ns = 1cycle @ 20MHz.",
      swaccess: "rw",
      hwaccess: "hro",
      fields: [
        {
            bits: "15:0",
            resval: 1
        }
      ]
    },
    { name: "tRD_P1",
      desc: "# clock cycles stay in RD_P1 state. This represents time from READEN activation to reading a valid DOUT. tRD = 200ns = 10cycles @ 50MHz. Note that this time cannot be longer than 1000ns to satisfy the maximum READEN high pulse width (see tRD_P2).",
      swaccess: "rw",
      hwaccess: "hro",
      fields: [
        {
            bits: "15:0",
            resval: 10
        }
      ]
    },
    { name: "tRD_P2",
      desc: "# clock cycles stay in RD_P2 state. This represents time from reading DOUT and READEN deactivation. In order to datisfy READEN min/max pulse width: tRD_P2+tRD_P1 shall be between 20ns and 1000ns i.e., 10 to 50 cycles @ 50MHz. For instance, if tRD_P1=10cycles, then tRD_P2 can go from 0 to 40 cycles @ 50MHz.",
      swaccess: "rw",
      hwaccess: "hro",
      fields: [
        {
            bits: "15:0",
            resval: 10
        }
      ]
    },
    { name: "tRD_P3",
      desc: "# clock cycles stay in RD_P3 state. This represents the time from READEN deactivation to the next valid address. tAH = 20ns = 1cycle @ 50MHz.",
      swaccess: "rw",
      hwaccess: "hro",
      fields: [
        {
            bits: "15:0",
            resval: 1
        }
      ]
    },
    { name: "tWR_P0",
      desc: "# clock cycles stay in WR_P0 state. This represents the time from end of last operation to apply new address. max(tAH, tRSTS) = 20ns. 1cycle @ 50MHz.",
      swaccess: "rw",
      hwaccess: "hro",
      fields: [
        {
            bits: "15:0",
            resval: 1
        }
      ]
    },
    { name: "tWR_P1",
      desc: "# clock cycles stay in WR_P1 state. This represents address to DLE / DATA time. tAS-min(tDS,tDLES)=tAS-20ns=0. Set to 1cycle @ 50MHz.",
      swaccess: "rw",
      hwaccess: "hro",
      fields: [
        {
            bits: "15:0",
            resval: 1
        }
      ]
    },
    { name: "tWR_P2",
      desc: "# clock cycles stay in WR_P2 state. This represents the time from DLE active to WEB active tDLES = min 20ns. 1cycle @ 50MHz",
      swaccess: "rw",
      hwaccess: "hro",
      fields: [
        {
            bits: "15:0",
            resval: 1
        }
      ]
    },
    { name: "tWR_P3",
      desc: "# clock cycles stay in WR_P3 state. This represents the width of the WEB signal, tWWL and should be min 20ns. 1cycle @ 50MHz.",
      swaccess: "rw",
      hwaccess: "hro",
      fields: [
        {
            bits: "15:0",
            resval: 1
        }
      ]
    },
    { name: "tWR_P4",
      desc: "# clock cycles stay in WR_P4 state. This represents WEB deactivation to DLE deactivation tDLEH = 20ns. 1cycle @ 50MHz.",
      swaccess: "rw",
      hwaccess: "hro",
      fields: [
        {
            bits: "15:0",
            resval: 1
        }
      ]
    },
    { name: "tWR_P5",
      desc: "# clock cycles stay in WR_P5 state. This represents th time between DLE deactivation and activation of PGMEN tDLES = 20ns min. 1 cycle @ 50MHz.",
      swaccess: "rw",
      hwaccess: "hro",
      fields: [
        {
            bits: "15:0",
            resval: 1
        }
      ]
    },
    { name: "tWR_P6",
      desc: "# clock cycles stay in WR_P6 state. This represents the time between activation of PGMEN to activation of CPUMPEN. tPES = 500ns (25 cycles @ 50MHz).",
      swaccess: "rw",
      hwaccess: "hro",
      fields: [
        {
            bits: "15:0",
            resval: 25
        }
      ]
    },
    { name: "tWR_P7",
      desc: "# clock cycles stay in INIT_WR_P7 state. This represents CPUMPEN activation to WEB pulse time tCPS. min 1us (50 cycles @ 50MHz).",
      swaccess: "rw",
      hwaccess: "hro",
      fields: [
        {
            bits: "15:0",
            resval: 50
        }
      ]
    },
    { name: "tWR_P8",
      desc: "# clock cycles stay in WR_P8 state. This represents the WEB low period for program cycles. tPW = 2us to 3us. Set to 2.5us (125 cycles @ 50MHz)",
      swaccess: "rw",
      hwaccess: "hro",
      fields: [
        {
            bits: "15:0",
            resval: 125
        }
      ]
    },
    { name: "tWR_P9",
      desc: "# clock cycles stay in WR_P8 state. This represents the time between deactivation of WEB to deactivation of CPUMPEN. tCPH = 500ns (25 cycles @ 50MHz).",
      swaccess: "rw",
      hwaccess: "hro",
      fields: [
        {
            bits: "15:0",
            resval: 25
        }
      ]
    },
    { name: "tWR_P10",
      desc: "# clock cycles stay in WR_P10 state. This represents the deactivation of CPUMPEN to deactivation of PGMEN. tPEH = 1us (50 cycles @ 50MHz).",
      swaccess: "rw",
      hwaccess: "hro",
      fields: [
        {
            bits: "15:0",
            resval: 50
        }
      ]
    },
    { name: "tWR_P11",
      desc: "# cycles in WR_P11 state. This represents deactivation of PGMEN to next operation time. tPGML = 20ns. Set to 1 cycle @ 50MHz.",
      swaccess: "rw",
      hwaccess: "hro",
      fields: [
        {
            bits: "15:0",
            resval: 1
        }
      ]
    },
    { name: "tWR_V0",
      desc: "# cycles in WR_P11 state. This represents deactivation of PGMEN to next operation time. tPGML = 20ns. Set to 1 cycle @ 50MHz.",
      swaccess: "rw",
      hwaccess: "hro",
      fields: [
        {
            bits: "15:0",
            resval: 1
        }
      ]
    },
    { name: "tRW_HLD",
      desc: "RSTB Pulse Width in cycles. (min. 20ns)",
      swaccess: "rw",
      hwaccess: "hro",
      fields: [
        {
            bits: "15:0",
            desc: '''RSTB Pulse Width in cycles.'''
            resval: 10
        }
      ]
    },
    { name: "tRR_HLD",
      desc: "RSTB Pulse Width in cycles. (min. 20ns)",
      swaccess: "rw",
      hwaccess: "hro",
      fields: [
        {
            bits: "15:0",
            desc: '''RSTB Pulse Width in cycles.'''
            resval: 10
        }
      ]
    },
  ]
}
