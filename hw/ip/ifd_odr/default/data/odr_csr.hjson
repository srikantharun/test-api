// Copyright lowRISC contributors.
// Licensed under the Apache License, Version 2.0, see LICENSE for details.
// SPDX-License-Identifier: Apache-2.0
{ name: "odr_csr",
  clocking: [{clock: "clk_i", reset: "rst_ni"}],
  bus_interfaces: [
    { protocol: "tlul", direction: "device" }
  ],
  regwidth: "64",
  addrcap: "0x10000",
  axi_intf: True
  param_list : [
    {name:"AXI_AW", type:"int", default:"28"},
    {name:"AXI_IDW", type:"int", default:"9"},
    {name:"AXI_LENW", type:"int", default:"8"}
  ]
  registers: [
    { name: "CMDBLK_CTRL",
      desc: "Control register of the CMD Block.",
      swaccess: "rw",
      hwaccess: "hro",
      fields: [
        {
            bits: "0",
            name: "EXEC_EN",
            desc: '''
                  While `EXEC_EN` is high, the block processes commands, that are pushed into the command FIFO.
                  ''',
            resval: 0x0
        }
        {
            bits: "1",
            name: "PTR_RST",
            desc: '''
                  Synchronous active-high reset of the command FIFO's input word pointer.
                  Set and unset `PTR_RST` to reset `CMDBLK_STATUS.IN_WORD_PTR` to 0. Only use this for error recovery.
                  ''',
            resval: 0x0
        }
      ]
    },
    { name: "CMDBLK_STATUS",
      desc: "Status register of the CMD Block.",
      swaccess: "ro",
      hwaccess: "hwo",
      hwext : True
      fields: [
        {
            bits: "1:0",
            name: "STATE",
            desc: '''
                  0: `IDLE` Command FIFO and fill buffer are both empty.
                  1: `FILL` Command FIFO is empty, but there is at least a header in the fill buffer
                  2: `READY` Command FIFO contains at least one item
                  3: `EXECUTE` Outstanding commands is at least 1
                  '''
        }
        {
            bits: "2",
            name: "WAIT_TOKEN",
            desc: '''
                  `WAIT_TOKEN` is high iff a command is waiting at the output buffer of the command FIFO for a token to arrive.
                  '''
        }
        {
            bits: "15:8",
            name: "IN_WORD_PTR",
            desc: '''
                  The input word pointer is used to construct the input data for the command FIFO and
                  points to the next 64bit word of the input data to be received by the next AXI transaction.
                  '''
        }
        {
            bits: "23:16",
            name: "FIFO_CNT",
            desc: '''Fill counter of the command FIFO.'''
        }
        {
            bits: "31:24",
            name: "OUTST_CMDS",
            desc: '''
                  Number of outstanding commands.
                  A command is outstanding iff it has been popped from the command FIFO and sent for execution,
                  but the datapath has not yet signaled that its execution has been done.
                  '''
        }
        {
            bits: "47:32",
            name: "PENDING_TOKENS",
            desc: '''
                  Signals which consume tokens are pending.
                  '''
        }
      ]
    },
    {
      name: "IRQ_EN",
      desc: "Interrupt enable register",
      swaccess: "rw",
      hwaccess: "hro",
      fields: [
        { bits: "0",
          name: "ERR_ADDR_OUT_OF_RANGE",
          desc: '''
                Enable IRQ flagging of address out of range
                '''
        }
        { bits: "1",
          name: "ERR_ILLEGAL_ADDR",
          desc: '''
                Enable IRQ flagging of address going beyond L1 memory range.
                '''
        }
        { bits: "2",
          name: "ERR_UNEXP_LAST_LOW",
          desc: '''
                Enable IRQ flagging of unexpected low last.
                '''
        }
        { bits: "3",
          name: "ERR_UNEXP_LAST_HIGH",
          desc: '''
                Enable IRQ flagging of unexpected high last.
                '''
        }
        { bits: "8",
          name: "CMDBLK_CMD_DROPPED",
          desc: '''
                Enable IRQ flagging of command block FIFO command dropping.
                '''
          resval: 0x1
        }
        { bits: "24",
          name: "DP_VTRSP_ACCESS_ERROR",
          desc: '''
                Enable IRQ flagging of VTRSP access error while not present
                '''
          resval: 0x1
        }
        { bits: "25",
          name: "ERR_VTRSP",
          desc: '''
                Enable IRQ flagging of VTRSP error
                '''
        }
        { bits: "26",
          name: "ERR_ILLEGAL_DATA_CONVERSION",
          desc: '''
                Enable IRQ flagging of ILLEGAL DATA CONVERSION Error.
                '''
        }
        { bits: "27",
          name: "ERR_ODD_NUMBER_INT8_CASTING",
          desc: '''
                Enable IRQ flagging of ODD NUMBER OF INT8_CASTING Error.
                '''
        }
        { bits: "32",
          name: "DBG_SW_INTERRUPT",
          desc: '''
                Enable IRQ flagging of the debug SW interrupt.
                '''
        }
      ]
    },
    {
      name: "IRQ_STATUS",
      desc: "Interrupt status register",
      swaccess: "rw1c",
      hwaccess: "hrw"
      fields: [
        { bits: "0",
          name: "ERR_ADDR_OUT_OF_RANGE",
          desc: '''
                The address generated by the address generator was out of specified range (range: base <= addr < base + bsize).
                '''
        }
        { bits: "1",
          name: "ERR_ILLEGAL_ADDR",
          desc: '''
                The address generated by the address generator was out of L1 range.
                '''
        }
        { bits: "2",
          name: "ERR_UNEXP_LAST_LOW",
          desc: '''
                The AXI-S Last line was low, but expected this to be high.
                '''
        }
        { bits: "3",
          name: "ERR_UNEXP_LAST_HIGH",
          desc: '''
                The AXI-S Last line was high, but expected this to be low.
                '''
        }
        { bits: "8",
          name: "CMDBLK_CMD_DROPPED",
          desc: '''
                The command block FIFO had to drop at least one command because the FIFO was already full.
                '''
        }
        { bits: "24",
          name: "DP_VTRSP_ACCESS_ERROR",
          desc: '''
                There was an attempt to use the VTRSP while it was not present (DP_STATUS.VTRSP_PRESENT==0)
                '''
        }
        { bits: "25",
          name: "ERR_VTRSP",
          desc: '''
                The VTRSP generated an error, set when a transpose is done on a block that is not an integer * `PWORD_LEN`
                '''
        }
        { bits: "26",
          name: "ERR_ILLEGAL_DATA_CONVERSION",
          desc: '''
                Illegal data conversion request, int8 to int16, has been received by ODR.
                '''
        }
        { bits: "27",
          name: "ERR_ODD_NUMBER_INT8_CASTING",
          desc: '''
                Odd number of PWORD32i16 data has been received at ODR which is not sufficient to pack and cast to PWORD64i8 data.
                '''
        }
        { bits: "32",
          name: "DBG_SW_INTERRUPT",
          desc: '''
                SW triggered the debug interrupt by setting the `DP_CTRL.DBG_SW_IRQ` to high.
                '''
        }
      ]
    },
    { name: "DP_CTRL",
      desc: "Control register of the datapath.",
      swaccess: "rw",
      hwaccess: "hro",
      fields: [
        {
            bits: "32",
            name: "DBG_SW_IRQ",
            desc: '''
                  `DBG_SW_IRQ` is a level-triggered interrupt request.
                  Set `DBG_SW_IRQ` to high to trigger the debug SW interrupt.
                  Interrupt handler must set `DBG_SW_IRQ` to low again.
                  '''
            resval: 0x0
        }
      ]
    },
    { name: "DP_STATUS",
      desc: "Datapath status observarion register.",
      swaccess: "ro",
      hwaccess: "hwo",
      hwext : True
      fields: [
        {
            bits: "0",
            name: "IN0_VLD",
            desc: '''Valid signal of the first input AXIS stream after input FIFO / buffer (if present).'''
        }
        {
            bits: "1",
            name: "IN0_RDY",
            desc: '''Ready signal of the first input AXIS stream after input FIFO / buffer (if present).'''
        }
        {
            bits: "2",
            name: "IN0_LST",
            desc: '''Last signal of the first input AXIS stream after input FIFO / buffer (if present).'''
        }
        {
            bits: "3",
            name: "IN0_STL",
            desc: '''Indicates a stall on the first input AXIS stream after input FIFO / buffer (if present).'''
        }
        // {
        //     bits: "4",
        //     name: "IN1_VLD",
        //     desc: '''Valid signal of the second input AXIS stream after input FIFO / buffer (if present).'''
        // }
        // {
        //     bits: "5",
        //     name: "IN1_RDY",
        //     desc: '''Ready signal of the second input AXIS stream after input FIFO / buffer (if present).'''
        // }
        // {
        //     bits: "6",
        //     name: "IN1_LST",
        //     desc: '''Last signal of the second input AXIS stream after input FIFO / buffer (if present).'''
        // }
        // {
        //     bits: "7",
        //     name: "IN1_STL",
        //     desc: '''Indicates a stall on the second input AXIS stream after input FIFO / buffer (if present).'''
        // }
        // {
        //     bits: "8",
        //     name: "OUT_VLD",
        //     desc: '''Valid signal of the output AXIS stream before output FIFO / buffer (if present).'''
        // }
        // {
        //     bits: "9",
        //     name: "OUT_RDY",
        //     desc: '''Ready signal of the output AXIS stream before output FIFO / buffer (if present).'''
        // }
        // {
        //     bits: "10",
        //     name: "OUT_LST",
        //     desc: '''Last signal of the output AXIS stream before output FIFO / buffer (if present).'''
        // }
        // {
        //     bits: "11",
        //     name: "OUT_STL",
        //     desc: '''Indicates a stall on the output AXIS stream before output FIFO / buffer (if present).'''
        // }
        {
            bits: "16",
            name: "DPCMD0_VLD",
            desc: '''Valid signal of the execution `DPcmd` AXIS stream after command FIFO / buffer (if present).'''
        }
        {
            bits: "17",
            name: "DPCMD0_RDY",
            desc: '''Ready signal of the execution `DPcmd` AXIS stream after command FIFO / buffer (if present).'''
        }
        {
            bits: "18",
            name: "DPCMD0_LST",
            desc: '''Last signal of the execution `DPcmd` AXIS stream after command FIFO / buffer (if present).'''
        }
        {
            bits: "19",
            name: "DPCMD0_STL",
            desc: '''Indicates a stall on the execution `DPcmd` AXIS stream after command FIFO / buffer (if present).'''
        }
        // {
        //     bits: "20",
        //     name: "DPCMD1_VLD",
        //     desc: '''Valid signal of the programming `DPcmd` AXIS stream after command FIFO / buffer (if present).'''
        // }
        // {
        //     bits: "21",
        //     name: "DPCMD1_RDY",
        //     desc: '''Ready signal of the programming `DPcmd` AXIS stream after command FIFO / buffer (if present).'''
        // }
        // {
        //     bits: "22",
        //     name: "DPCMD1_LST",
        //     desc: '''Last signal of the programming `DPcmd` AXIS stream after command FIFO / buffer (if present).'''
        // }
        // {
        //     bits: "23",
        //     name: "DPCMD1_STL",
        //     desc: '''Indicates a stall on the programming `DPcmd` AXIS stream after command FIFO / buffer (if present).'''
        // }
        {
            bits: "32",
            name: "MM_REQ_VLD",
            desc: '''Valid signal of the MMIO request chanel at the datapath input.'''
        }
        {
            bits: "33",
            name: "MM_REQ_RDY",
            desc: '''Ready signal of the MMIO request channel at the datapath input.'''
        }
        {
            bits: "34",
            name: "MM_RESP_ACK",
            desc: '''Acknowledge signal of the MMIO response channel at the datapath input.'''
        }
        // VTRSP additions compared to IFD
        {
            bits: "50:48",
            name: "VTRSP_FILL_STATE",
            desc: '''Current fill state of the VTRSP buffer.'''
        }
        {
            bits: "52:51",
            name: "VTRSP_DRAIN_STATE",
            desc: '''Current drain state of the VTRSP buffer.'''
        }
        {
            bits: "53",
            name: "VTRSP_IN_LST",
            desc: '''Last signal of the VTRSP input AXIS stream after input FIFO / buffer (if present).'''
        }
        {
            bits: "54",
            name: "VTRSP_IN_RDY",
            desc: '''Ready signal of the VTRSP input AXIS stream after input FIFO / buffer (if present).'''
        }
        {
            bits: "55",
            name: "VTRSP_IN_VLD",
            desc: '''Valid signal of the VTRSP input AXIS stream after input FIFO / buffer (if present).'''
        }
        {
            bits: "56",
            name: "VTRSP_OUT_LST",
            desc: '''Last signal of the VTRSP output AXIS stream before output FIFO / buffer (if present).'''
        }
        {
            bits: "57",
            name: "VTRSP_OUT_RDY",
            desc: '''Ready signal of the VTRSP output AXIS stream before output FIFO / buffer (if present).'''
        }
        {
            bits: "58",
            name: "VTRSP_OUT_VLD",
            desc: '''Valid signal of the VTRSP output AXIS stream before output FIFO / buffer (if present).'''
        }
        {
            bits: "59",
            name: "VTRSP_CMD_LST",
            desc: '''Last signal of the VTRSP command AXIS stream after command FIFO / buffer (if present).'''
        }
        {
            bits: "60",
            name: "VTRSP_CMD_RDY",
            desc: '''Ready signal of the VTRSP command AXIS stream after command FIFO / buffer (if present).'''
        }
        {
            bits: "61",
            name: "VTRSP_CMD_VLD",
            desc: '''Valid signal of the VTRSP command AXIS stream after command FIFO / buffer (if present).'''
        }
      ]
    },
    { name: "DBG_OBSERVE",
      desc: "Observation register.",
      swaccess: "ro",
      hwaccess: "hwo",
      hwext : True
      fields: [
        {
            bits: "0",
            name: "IN0_VLD",
            desc: '''Valid signal of the first input AXIS stream.'''
        }
        {
            bits: "1",
            name: "IN0_RDY",
            desc: '''Ready signal of the first input AXIS stream.'''
        }
        {
            bits: "2",
            name: "IN0_LST",
            desc: '''Last signal of the first input AXIS stream.'''
        }
        // {
        //     bits: "4",
        //     name: "IN1_VLD",
        //     desc: '''Valid signal of the second input AXIS stream.'''
        // }
        // {
        //     bits: "5",
        //     name: "IN1_RDY",
        //     desc: '''Ready signal of the second input AXIS stream.'''
        // }
        // {
        //     bits: "6",
        //     name: "IN1_LST",
        //     desc: '''Last signal of the second input AXIS stream.'''
        // }
        // {
        //     bits: "8",
        //     name: "OUT_VLD",
        //     desc: '''Valid signal of the output AXIS stream.'''
        // }
        // {
        //     bits: "9",
        //     name: "OUT_RDY",
        //     desc: '''Ready signal of the output AXIS stream.'''
        // }
        // {
        //     bits: "10",
        //     name: "OUT_LST",
        //     desc: '''Last signal of the output AXIS stream.'''
        // }
        {
            bits: "16",
            name: "DPCMD0_VLD",
            desc: '''Valid signal of the execution `DPcmd` AXIS stream after multiplexer.'''
        }
        {
            bits: "17",
            name: "DPCMD0_RDY",
            desc: '''Ready signal of the execution `DPcmd` AXIS stream after multiplexer.'''
        }
        {
            bits: "18",
            name: "DPCMD0_LST",
            desc: '''Last signal of the execution `DPcmd` AXIS stream after multiplexer.'''
        }
        // {
        //     bits: "20",
        //     name: "DPCMD1_VLD",
        //     desc: '''Valid signal of the programming `DPcmd` AXIS stream after multiplexer.'''
        // }
        // {
        //     bits: "21",
        //     name: "DPCMD1_RDY",
        //     desc: '''Ready signal of the programming `DPcmd` AXIS stream after multiplexer.'''
        // }
        // {
        //     bits: "22",
        //     name: "DPCMD1_LST",
        //     desc: '''Last signal of the programming `DPcmd` AXIS stream after multiplexer.'''
        // }
      ]
    },
    { name: "CMDGEN_STATUS",
      desc: "Address generator observation register.",
      swaccess: "ro",
      hwaccess: "hwo",
      hwext : True
      fields: [
        // {
        //     bits: "31:0",
        //     name: "ITERATION_CNT",
        //     desc: '''Iteration counter of the currently executed loop.'''
        // }
        // {
        //     bits: "47:32",
        //     name: "PROGRAM_CNT",
        //     desc: '''Current program counter (instruction memory pointer) value.'''
        // }
        {
            bits: "49:48",
            name: "FSM_STATE",
            desc: '''Address generator FSM state.'''
        }
        {
            bits: "50",
            name: "INSTR_STALLED",
            desc: '''A value of 1 indicates that the address generator is stalled.'''
        }
        {
            bits: "51",
            name: "OUT_A_ZERO",
            desc: '''A value of 1 indicates that the out_a counter value has reached zero.'''
        }
        {
            bits: "52",
            name: "OUT_B_ZERO",
            desc: '''A value of 1 indicates that the out_b counter value has reached zero.'''
        }
        {
            bits: "53",
            name: "OUT_C_ZERO",
            desc: '''A value of 1 indicates that the out_c counter value has reached zero.'''
        }
        {
            bits: "54",
            name: "OUT_D_ZERO",
            desc: '''A value of 1 indicates that the out_c counter value has reached zero.'''
        }
        {
            bits: "55",
            name: "INNER_A_ZERO",
            desc: '''A value of 1 indicates that the inner_a counter value has reached zero.'''
        }
        {
            bits: "56",
            name: "INNER_B_ZERO",
            desc: '''A value of 1 indicates that the inner_b counter value has reached zero.'''
        }
        {
            bits: "57",
            name: "INNER_C_ZERO",
            desc: '''A value of 1 indicates that the inner_c counter value has reached zero.'''
        }
        {
            bits: "58",
            name: "INNER_D_ZERO",
            desc: '''A value of 1 indicates that the inner_c counter value has reached zero.'''
        }
      ]
    },
    { name: "DBG_SCRATCH",
      desc: "Scratch register only accessible through SW for debugging purposes.",
      swaccess: "rw",
      hwaccess: "none"
      fields: [
        {
            bits: "63:0",
            name: "SCRATCH",
            desc: '''Scratch register field.''',
            resval: 0x0
        }
      ]
    },
    { name: "DBG_ID",
      desc: "Block identification register.",
      swaccess: "ro",
      hwaccess: "hwo",
      hwext : True
      fields: [
        {
            bits: "7:0",
            name: "BLOCK_ID",
            desc: '''Unique identifier of an `AI Core` block. Note, that the same blocks in each `AI Core` instance share the same `BLOCK_ID`.'''
        }
        {
            bits: "15:8",
            name: "AI_CORE_ID",
            desc: '''`AI_CORE_ID` aka `CID` is a unique identifier of the `AI Core` instance.'''
        }
        {
            bits: "23:16",
            name: "HW_REVISION",
            desc: '''Major hardware revision number.'''
        }
      ]
    },
    { name: "HW_CAPABILITY",
      desc: "Hardware capability register for the instance.",
      swaccess: "ro",
      hwaccess: "hwo",
      hwext : True
      fields: [
        {
            bits: "7:0",
            name: "CMD_FIFO_DEPTH",
            desc: '''Depth of the command FIFO in the CMD block.'''
        }
        // {
        //      bits: "31:16",
        //      name: "INSTR_MEM_DEPTH",
        //      desc: '''Depth of the instruction memory in the `DPcmdgen` block, measured in number of instructions.'''
        // }
        {
             bits: "32",
             name: "STATIC_CMD_PRESENT",
             desc: '''If set to high, the static part of the command block is present.'''
        }
        {
            bits: "34",
            name: "VTRSP_PRESENT",
            desc: '''If set to high, the VTRSP block is present in the instance'''
        }
      ]
    }
  ]
}
