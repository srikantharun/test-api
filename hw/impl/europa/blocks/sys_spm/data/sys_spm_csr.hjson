// (C) Copyright 2024 Axelera AI B.V.
// All Rights Reserved
// *** Axelera AI Confidential ***
//
// Owner: Yasen Kazandzhiev <yasen.kazandzhiev@axelera.ai>
//
// Description: hjson desc for SysSPM CSRs

// Copyright lowRISC contributors.
// Licensed under the Apache License, Version 2.0, see LICENSE for details.
// SPDX-License-Identifier: Apache-2.0
{ name: "sys_spm_csr",
  clocking: [{clock: "clk_i", reset: "rst_ni"}],
  bus_interfaces: [
    { protocol: "tlul", direction: "device" }
  ],
  regwidth: "32",
  addrcap: "0x10000",
  axi_intf: False
  param_list : [
    {name:"AW", type:"int", default:"16"}
  ]
  registers: [
    { skipto: "0x200" },
    { name: "SCP_ERR_DISABLE",
      desc: "Sys controller spm memory ECC error disable",
      swaccess: "wo",
      hwaccess: "hro",
      fields: [
        {
            name: "ECC_ERR_DISABLE",
            bits: "0",
            desc: '''Scratchpad error disable (disables error reporting and returns non repaired data)
            '''
            resval: 0x0
        }
      ]
    },
    { name: "SCP_ERR_STATUS",
      desc: "Sys controller spm memory ECC error status register",
      swaccess: "ro",
      hwaccess: "hwo",
      fields: [
        {
            name: "ECC_ERR_PRESENT",
            bits: "0",
            desc: '''Scratchpad error indication (0:not present, 1:present)
            '''
        }
        {
            name: "ECC_ERR_TYPE",
            bits: "1",
            desc: '''Scratchpad error type (0: single bit error, 1: double bit error)
            '''
        }
        {
            name: "ECC_ERR_SYNDROME",
            bits: "9:2",
            desc: '''Scratchpad error syndrome
            '''
        }
        {
            name: "ECC_ERR_INDEX",
            bits: "29:10",
            desc: '''Scratchpad error index (20-bit address in memory max 8MiB)
            '''
        }
      ]
    },
    { name: "SCP_MEM_POWER_MODE",
      desc: "Control Register to select the power mode of the Sys-SPM memory.",
      swaccess: "rw",
      hwaccess: "hro"
      fields: [
        {
            bits: "0",
            name: "ret",
            desc: '''
                  Retention mode enable, active high
                  When PDE is high and RET are low, the memory operates in the power-down
                  mode. However, when PDE is high and RET is high, you can control the retention
                  voltage of the core by varying VDDCE.
                  '''
            resval: 0x0
        }
        {
            bits: "1",
            name: "pde",
            desc: '''
                  Power down enable, active high
                  During normal SRAM operation, this signal must be low to enable power gates.
                  When high, the retention mode or power-down mode is enable.
                  '''
            resval: 0x0
        }
      ]
    },
    { name: "SCP_MEM_POWER_UP_READY",
      desc: "Status Register that indicates the Ready for Operation of the Sys-SPM memory.",
      swaccess: "ro",
      hwaccess: "hwo",
      hwext: "true",
      fields: [
        {
            bits: "0",
            name:"prn",
            desc: '''
                  Power up ready negative
                  When entering normal mode from power mode, PRN is changed from 1 to 0 to
                  notify that power up is completed.'''
        }
      ]
    }
  ]
}

