// Copyright lowRISC contributors.
// Licensed under the Apache License, Version 2.0, see LICENSE for details.
// SPDX-License-Identifier: Apache-2.0
{ name: "l2_csr",
  clocking: [{clock: "clk_i", reset: "rst_ni"}],
  bus_interfaces: [
    { protocol: "tlul", direction: "device" }
  ],
  regwidth: "32",
  addrcap: "0x1000",
  axi_intf: False
  param_list : [
    {name:"AW", type:"int", default:"16"}
  ]
  registers: [
    { skipto: "0x200" }
    { name: "MEM_POWER_MODE_L2",
      desc: "Control Register to select the power mode of the L2 memory.",
      swaccess: "rw",
      hwaccess: "hro"
      fields: [
        {
            bits: "0",
            name: "ret",
            desc: '''
                  Retention mode enable, active high
                  When PDE is high and RET are low, the memory operates in the power-down
                  mode. However, when PDE is high and RET is high, you can control the retention
                  voltage of the core by varying VDDCE.
                  '''
            resval: 0x0
        }
        {
            bits: "1",
            name: "pde",
            desc: '''
                  Power down enable, active high
                  During normal SRAM operation, this signal must be low to enable power gates.
                  When high, the retention mode or power-down mode is enable.
                  '''
            resval: 0x0
        }
      ]
    },
    { name: "MEM_POWER_UP_READY_L2",
      desc: "Status Register that indicates the Ready for Operation of the L2 memory.",
      swaccess: "ro",
      hwaccess: "hwo",
      hwext: "true",
      fields: [
        {
            bits: "0",
            name:"prn",
            desc: '''
                  Power up ready negative
                  When entering normal mode from power mode, PRN is changed from 1 to 0 to
                  notify that power up is completed.'''
        }
      ]
    }
  ]
}
