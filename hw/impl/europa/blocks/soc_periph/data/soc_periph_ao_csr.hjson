// Copyright lowRISC contributors.
// Licensed under the Apache License, Version 2.0, see LICENSE for details.
// SPDX-License-Identifier: Apache-2.0
{ name: "soc_periph_ao_csr",
  clocking: [{clock: "clk_i", reset: "rst_ni"}],
  bus_interfaces: [
    { protocol: "tlul", direction: "device" }
  ],
  regwidth: "32",
  addrcap: "0x1000",
  axi_intf: False
  param_list : [
    {name:"AW", type:"int", default:"16"}
  ]
  registers: [
    { skipto: "0x200" }
    { name: "PADCTRL_REF_CLK",
      desc: "Control register for the ref_clk pad.",
      swaccess: "rw",
      hwaccess: "hro"
      fields: [
        {
            bits: "1:0",
            name: "sel_freq",
            desc: '''
                  REF_CLK pad frequency selection control.
                  '''
            resval: 0x0
        }
      ] 
    }
    { name: "IO_DS_JTAG",
      desc: "IO-cell drivestrength setting for jtag related output IO-cells.",
      swaccess: "rw",
      hwaccess: "hro",
      fields: [
        {
            bits: "1:0",
            desc: '''Drive strenght vector'''
            resval: 0x3
        }
      ]
    },
    { name: "IO_DS_UART",
      desc: "IO-cell drivestrength setting for uart related output IO-cells.",
      swaccess: "rw",
      hwaccess: "hro",
      fields: [
        {
            bits: "1:0",
            desc: '''Drive strenght vector'''
            resval: 0x3
        }
      ]
    },
    { name: "IO_DS_SPI",
      desc: "IO-cell drivestrength setting for spi related output IO-cells.",
      swaccess: "rw",
      hwaccess: "hro",
      fields: [
        {
            bits: "1:0",
            desc: '''Drive strenght vector'''
            resval: 0x3
        }
      ]
    },
    { name: "IO_DS_I2C",
      desc: "IO-cell drivestrength setting for i2c related output IO-cells.",
      swaccess: "rw",
      hwaccess: "hro",
      fields: [
        {
            bits: "1:0",
            desc: '''Drive strenght vector'''
            resval: 0x3
        }
      ]
    },
    { name: "IO_DS_GPIO",
      desc: "IO-cell drivestrength setting for gpio related output IO-cells.",
      swaccess: "rw",
      hwaccess: "hro",
      fields: [
        {
            bits: "1:0",
            desc: '''Drive strenght vector'''
            resval: 0x3
        }
      ]
    },
    { name: "IO_DS_EMMC",
      desc: "IO-cell drivestrength setting for emmc related output IO-cells.",
      swaccess: "rw",
      hwaccess: "hro",
      fields: [
        {
            bits: "1:0",
            desc: '''Drive strenght vector'''
            resval: 0x3
        }
      ]
    },
    { name: "IO_DS_OBS",
      desc: "IO-cell drivestrength setting for obs related output IO-cells.",
      swaccess: "rw",
      hwaccess: "hro",
      fields: [
        {
            bits: "1:0",
            desc: '''Drive strenght vector'''
            resval: 0x3
        }
      ]
    },
    { name: "IO_DS_DFT",
      desc: "IO-cell drivestrength setting for dft related output IO-cells.",
      swaccess: "rw",
      hwaccess: "hro",
      fields: [
        {
            bits: "2:0",
            desc: '''Drive strenght vector'''
            resval: 0x7
        }
      ]
    },
    { name: "IO_ST_CLK",
      desc: "IO-cell Schmitt Trigger settings for CLK",
      swaccess: "rw",
      hwaccess: "hro",
      fields: [
        {
            bits: "0:0",
            desc: '''Schmitt Trigger Enable'''
            resval: 0x1
        }
      ]
    },
    { name: "IO_ST_RST",
      desc: "IO-cell Schmitt Trigger settings for RST",
      swaccess: "rw",
      hwaccess: "hro",
      fields: [
        {
            bits: "0:0",
            desc: '''Schmitt Trigger Enable'''
            resval: 0x1
        }
      ]
    },
    { name: "IO_ST_SPI",
      desc: "IO-cell Schmitt Trigger settings for SPI",
      swaccess: "rw",
      hwaccess: "hro",
      fields: [
        {
            bits: "0:0",
            desc: '''Schmitt Trigger Enable'''
            resval: 0x1
        }
      ]
    },
    { name: "IO_ST_UART",
      desc: "IO-cell Schmitt Trigger settings for UART",
      swaccess: "rw",
      hwaccess: "hro",
      fields: [
        {
            bits: "0:0",
            desc: '''Schmitt Trigger Enable'''
            resval: 0x1
        }
      ]
    },
    { name: "IO_ST_I2C",
      desc: "IO-cell Schmitt Trigger settings for I2C",
      swaccess: "rw",
      hwaccess: "hro",
      fields: [
        {
            bits: "0:0",
            desc: '''Schmitt Trigger Enable'''
            resval: 0x1
        }
      ]
    },
    { name: "IO_ST_GPIO",
      desc: "IO-cell Schmitt Trigger settings for GPIO",
      swaccess: "rw",
      hwaccess: "hro",
      fields: [
        {
            bits: "0:0",
            desc: '''Schmitt Trigger Enable'''
            resval: 0x1
        }
      ]
    },
    { name: "IO_ST_EMMC",
      desc: "IO-cell Schmitt Trigger settings for EMMC",
      swaccess: "rw",
      hwaccess: "hro",
      fields: [
        {
            bits: "0:0",
            desc: '''Schmitt Trigger Enable'''
            resval: 0x1
        }
      ]
    },
    { name: "IO_ST_DFT",
      desc: "IO-cell Schmitt Trigger settings for DFT",
      swaccess: "rw",
      hwaccess: "hro",
      fields: [
        {
            bits: "0:0",
            desc: '''Schmitt Trigger Enable'''
            resval: 0x1
        }
      ]
    },
    { name: "s0_hwinit_srs16",
      desc: "EMMC Capabilities Register 1",
      swaccess: "rw",
      hwaccess: "hro",
      fields: [
        {
          bits: "31:0",
          name: "SRS16RW",
          desc: "EMCC SRS16 Register[1]."
          resval: "191498400"
        }	  	 	
       ]
     },
     { name: "s0_hwinit_srs17",
       desc: "EMMC Capabilities Register 2",
       swaccess: "rw",
       hwaccess: "hro",
       fields: [
         {
          bits: "31:0"
          name: "SRS17RW",
          desc: "EMCC Capabilities Register[2]."
          resval: "0"
        }
       ]
    },     
    { name: "s0_hwinit_srs18",
      desc: "EMMC Capabilities Register 3",
      swaccess: "rw",
      hwaccess: "hro",
      fields: [
         {
          bits: "31:0"
          name: "SRS18RW",
          desc: "EMMC Capabilities Register[3]."
          resval: "0"
         }	
       ]
     },			 	         								
    { name: "s0_hwinit_srs19",
      desc: "EMMC Capabilities Register 4",
      swaccess: "rw",
      hwaccess: "hro",
      fields: [
         {
          bits: "31:0"
          name: "SRS19RW",
          desc: "EMMC Capabilities Register[4]."
          resval: "0"
         }	
       ]
     },
    { name: "s0_hwinit_srs24",
      desc: "EMMC Capabilities Register 5",
      swaccess: "rw",
      hwaccess: "hro",
      fields: [
         {
          bits: "31:0"
          name: "SRS24RW",
          desc: "EMMC Capabilities Register[5]."
          resval: "262144"
         }	 	
       ]
    },
    { name: "s0_hwinit_srs25",
      desc: "EMMC Capabilities Register 6",
      swaccess: "rw",
      hwaccess: "hro",
      fields: [
         {
          bits: "31:0"
          name: "SRS25RW",
          desc: "EMMC Capabilities Register[6]."
          resval: "262146"
         }	 	 	
       ]
    },
    { name: "s0_hwinit_srs26",
      desc: "EMMC Capabilities Register 7",
      swaccess: "rw",
      hwaccess: "hro",
      fields: [
         {
          bits: "31:0"
          name: "SRS26RW",
          desc: "EMMC Capabilities Register[7]."
          resval: "65538"
         }	 	 	
       ]
    },
    { name: "s0_hwinit_srs27",
      desc: "EMMC Capabilities Register 8",
      swaccess: "rw",
      hwaccess: "hro",
      fields: [
         {
          bits: "31:0"
          name: "SRS27RW",
          desc: "EMMC Capabilities Register[8]."
          resval: "131072"
         }	 	 	
       ]
    },
    { name: "hwinit_itcfmul",
      desc: "EMMC Command Queing Clock Multiplier Setup Register",
      swaccess: "rw",
      hwaccess: "hro",
      fields: [
         {
          bits: "3:0"
          name: "ITCFMUL",
          desc: "Internal Timer Clock Frequency Multiplier."
          resval: "0"
         }	 	 	
       ]
    },
    { name: "hwinit_itcfval",
      desc: "EMMC Command Queing Clock Value Setup Register",
      swaccess: "rw",
      hwaccess: "hro",
      fields: [
         {
          bits: "9:0"
          name: "ITCFVAL",
          desc: "Internal Timer Clock Value."
          resval: "0"
         }	 	 	
       ]
    },
    { name: "hwinit_itcfsel",
      desc: "EMMC Command Queing Clock Select Register",
      swaccess: "rw",
      hwaccess: "hro",
      fields: [
         {
          bits: "4:0"
          name: "ITCFSEL",
          desc: "Internal Queing Clock Select Value."
          resval: "0"
         }	 	 	
       ]
    },
    { name: "ics",
      desc: "EMMC Internal Clock Stable",
      swaccess: "rw",
      hwaccess: "hro",
      fields: [
         {
          bits: "0:0"
          name: "icsClockStable",
          desc: "EMMC internal clock stable."
          resval: "0"
         }	 	 	
       ]
    },
    { name: "ice",
      desc: "EMMC Internal Clock Stable",
      swaccess: "ro",
      hwaccess: "hwo",
      fields: [
         {
          bits: "0:0"
          name: "iceClockEnable",
          desc: "EMMC internal clock enable."
          resval: "0"
         }	 	 	
       ]
    }                    	     							     
    { name: "IO_SPI_DATA_PD_EN",
      desc: "IO-cell Pull Down settings for SPI Data",
      swaccess: "rw",
      hwaccess: "hro",
      fields: [
        {
            name: SPI_SD0_PD_EN
            bits: "0:0",
            desc: '''SPI SD0 Pull Down Enable'''
            resval: 0x1
        }
        {
            name: SPI_SD1_PD_EN
            bits: "1:1",
            desc: '''SPI SD1 Pull Down Enable'''
            resval: 0x1
        }
        {
            name: SPI_SD2_PD_EN
            bits: "2:2",
            desc: '''SPI SD2 Pull Down Enable'''
            resval: 0x1
        }
        {
            name: SPI_SD3_PD_EN
            bits: "3:3",
            desc: '''SPI SD3 Pull Down Enable'''
            resval: 0x1
        }
      ]
    },
    { name: "IO_BOOTMODE_PULL_EN",
      desc: "IO-cell Pull Down settings for BootMode",
      swaccess: "rw",
      hwaccess: "hro",
      fields: [
        {
            name: BOOTMODE_0_PU_EN
            bits: "0:0",
            desc: '''BOOTMODE0 Pull Up Enable'''
            resval: 0x1
        }
        {
            name: BOOTMODE_1_PD_EN
            bits: "1:1",
            desc: '''BOOTMODE1 Pull Down Enable'''
            resval: 0x1
        }
        {
            name: BOOTMODE_2_PD_EN
            bits: "2:2",
            desc: '''BOOTMODE2 Pull Down Enable'''
            resval: 0x1
        }
      ]
    },
    { name: "IO_UART_PD_EN",
      desc: "IO-cell Pull Down settings for UART inputs",
      swaccess: "rw",
      hwaccess: "hro",
      fields: [
        {
            name: UART_CTS_N_PD_EN
            bits: "0:0",
            desc: '''UART CTS_N Pull Down Enable'''
            resval: 0x1
        }
        {
            name: UART_RX_PD_EN
            bits: "1:1",
            desc: '''UART RX Data Pull Down Enable'''
            resval: 0x1
        }
      ]
    },
    { name: "IO_GPIO_PD_EN",
      desc: "IO-cell Pull Down settings for GPIOs",
      swaccess: "rw",
      hwaccess: "hro",
      fields: [
        {
            name: GPIO_0_PD_EN
            bits: "0:0",
            desc: '''GPIO0 Pull Down Enable'''
            resval: 0x1
        }
        {
            name: GPIO_1_PD_EN
            bits: "1:1",
            desc: '''GPIO1 Pull Down Enable'''
            resval: 0x1
        }
        {
            name: GPIO_2_PD_EN
            bits: "2:2",
            desc: '''GPIO2 Pull Down Enable'''
            resval: 0x1
        }
        {
            name: GPIO_3_PD_EN
            bits: "3:3",
            desc: '''GPIO3 Pull Down Enable'''
            resval: 0x1
        }
        {
            name: GPIO_4_PD_EN
            bits: "4:4",
            desc: '''GPIO4 Pull Down Enable'''
            resval: 0x1
        }
        {
            name: GPIO_5_PD_EN
            bits: "5:5",
            desc: '''GPIO5 Pull Down Enable'''
            resval: 0x1
        }
        {
            name: GPIO_6_PD_EN
            bits: "6:6",
            desc: '''GPIO6 Pull Down Enable'''
            resval: 0x1
        }
        {
            name: GPIO_7_PD_EN
            bits: "7:7",
            desc: '''GPIO7 Pull Down Enable'''
            resval: 0x1
        }
        {
            name: GPIO_8_PD_EN
            bits: "8:8",
            desc: '''GPIO8 Pull Down Enable'''
            resval: 0x1
        }
        {
            name: GPIO_9_PD_EN
            bits: "9:9",
            desc: '''GPIO9 Pull Down Enable'''
            resval: 0x1
        }
        {
            name: GPIO_10_PD_EN
            bits: "10:10",
            desc: '''GPIO10 Pull Down Enable'''
            resval: 0x1
        }
        {
            name: GPIO_11_PD_EN
            bits: "11:11",
            desc: '''GPIO11 Pull Down Enable'''
            resval: 0x1
        }
        {
            name: GPIO_12_PD_EN
            bits: "12:12",
            desc: '''GPIO12 Pull Down Enable'''
            resval: 0x1
        }
        {
            name: GPIO_13_PD_EN
            bits: "13:13",
            desc: '''GPIO13 Pull Down Enable'''
            resval: 0x1
        }
        {
            name: GPIO_14_PD_EN
            bits: "14:14",
            desc: '''GPIO14 Pull Down Enable'''
            resval: 0x1
        }
        {
            name: GPIO_15_PD_EN
            bits: "15:15",
            desc: '''GPIO15 Pull Down Enable'''
            resval: 0x1
        }
      ]
    },
  ]
}
