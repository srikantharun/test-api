// (C) Copyright Axelera AI 2024
// All Rights Reserved
// *** Axelera AI Confidential ***
{ name: "soc_mgmt_misc_csr",
  clocking: [{clock: "clk_i", reset: "rst_ni"}],
  bus_interfaces: [{ protocol: "tlul", direction: "device" }],
  regwidth: "32",
  addrcap: "0x10000",
  param_list : [
    {name:"C2C_CONSTANTS_GRP", type:"int", default:"2"},
  ]
  registers: [
    { name: "OBS_MUX_SELECT",
      desc: "Select the 16 signals for observability.",
      swaccess: "rw",
      hwaccess: "hro",
      fields:[
        { bits: "4:0",
          resval: "0",
          enum: [
            { value:  "0", name: "OBS_AIC_0", desc: "Select the observability signals from AI-Core 0."},
            { value:  "1", name: "OBS_AIC_1", desc: "Select the observability signals from AI-Core 1."},
            { value:  "2", name: "OBS_AIC_2", desc: "Select the observability signals from AI-Core 2."},
            { value:  "3", name: "OBS_AIC_3", desc: "Select the observability signals from AI-Core 3."},
            { value:  "4", name: "OBS_AIC_4", desc: "Select the observability signals from AI-Core 4."},
            { value:  "5", name: "OBS_AIC_5", desc: "Select the observability signals from AI-Core 5."},
            { value:  "6", name: "OBS_AIC_6", desc: "Select the observability signals from AI-Core 6."},
            { value:  "7", name: "OBS_AIC_7", desc: "Select the observability signals from AI-Core 7."},
            { value:  "8", name: "OBS_LPDDR_GRAPH_0", desc: "Select the observability signals from LPDDR GRAPH 0."},
            { value:  "9", name: "OBS_LPDDR_GRAPH_1", desc: "Select the observability signals from LPDDR GRAPH 1."},
            { value: "10", name: "OBS_LPDDR_GRAPH_2", desc: "Select the observability signals from LPDDR GRAPH 2."},
            { value: "11", name: "OBS_LPDDR_GRAPH_3", desc: "Select the observability signals from LPDDR GRAPH 3."},
            { value: "12", name: "OBS_LPDDR_PPP_0", desc: "Select the observability signals from LPDDR PPP 0."},
            { value: "13", name: "OBS_LPDDR_PPP_1", desc: "Select the observability signals from LPDDR PPP 1."},
            { value: "14", name: "OBS_LPDDR_PPP_2", desc: "Select the observability signals from LPDDR PPP 2."},
            { value: "15", name: "OBS_LPDDR_PPP_3", desc: "Select the observability signals from LPDDR PPP 3."},
            { value: "16", name: "OBS_PCIE", desc: "Select the observability signals from PCIE."},
          ],
        },
      ],
    },
    { name: "GLOBAL_SYNC",
      desc: "Global Sync signal",
      swaccess: "rw",
      hwaccess: "hro",
      fields: [
        { bits: "0",
          name: "SYNC",
          desc: '''This signal is used to set the global sync output.'''
          resval: "0"
        }
      ]
    },
    { name: "BOOT_MODE",
      desc: "Boot mode signal",
      swaccess: "rw",
      hwaccess: "hwo",
      fields: [
        { bits: "2:0",
          name: "boot_mode",
          desc: '''This signal is sampled at cold reset and overwrittable by APU'''
          resval: "0"
        }
      ]
    },
    { name: "C2C_CONTROL",
      desc: "Set C2C CORE Monitor",
      swaccess: "rw",
      hwaccess: "hro",
      fields: [
        {
            bits: "0",
            name: "enable",
            resval: 0,
            desc: '''
                  Enable C2C monitor
                  '''
        }
        {
            bits: "5:1",
            name: "voting_cfg",
            resval: 0,
            desc: '''
                  Selects voting configuration:
                  0: c2c_0
                  1: c2c_1
                  2: c2c_2
                  3: medium_vote
                  '''
        }
        {
            bits: "7:6",
            name: "scale",
            resval: 0,
            desc: '''
                  Scale factoring to compensate margin result
                  margin_result = margin_calculated >> scale
                  '''
        }
      ]
    },
    { multireg:
      { name: "C2C_CONSTANTS_AB",
        count: "C2C_CONSTANTS_GRP",
        cname: "c2ccntid",
        compact: false,
        desc: '''
        Set the constants used to calculate the margin
        `margin = constA*NLVT*NSVT + constB*NSVT + constC*NLVT + constD`
        ''',
        swaccess: "rw",
        hwaccess: "hro",
        fields: [
          {
              bits: "3:0",
              name: "A",
              resval: 0,
              desc: '''
                    Constant A
                    '''
          }
          {
              bits: "13:4",
              name: "B",
              resval: 0,
              desc: '''
                    Constant B
                    '''
          }
        ]
      }
    },
    { multireg:
      { name: "C2C_CONSTANTS_CD",
        count: "C2C_CONSTANTS_GRP",
        cname: "c2ccntid",
        compact: false,
        desc: '''
        Set the constants used to calculate the margin
        `margin = constA*NLVT*NSVT + constB*NSVT + constC*NLVT + constD`
        ''',
        swaccess: "rw",
        hwaccess: "hro",
        fields: [
          {
              bits: "9:0",
              name: "C",
              resval: 0,
              desc: '''
                    Constant C
                    '''
          }
          {
              bits: "29:10",
              name: "D",
              resval: 0,
              desc: '''
                    Constant D
                    '''
          }
        ]
      }
    },
    { name: "C2C_MARGIN",
      desc: "Margin for the C2C VDD",
      swaccess: "ro",
      hwaccess: "hwo",
      fields: [
        {
            bits: "7:0",
            name: "margin",
            resval: 0,
            desc: '''
                  Minimum between margin 1 and margin 2
                  '''
        }
      ]
    },
    { name: "MEM_POWER_MODE",
      desc: "Power Modes Control.",
      swaccess: "rw",
      hwaccess: "hro"
      fields: [
        {
            bits: "0",
            name: "ret",
            desc: '''
                  Retention mode enable, active high
                  When PDE is high and RET are low, the memory operates in the power-down
                  mode. However, when PDE is high and RET is high, you can control the retention
                  voltage of the core by varying VDDCE.
                  '''
            resval: 0x0
        }
        {
            bits: "1",
            name: "pde",
            desc: '''
                  Power down enable, active high
                  During normal SRAM operation, this signal must be low to enable power gates.
                  When high, the retention mode or power-down mode is enable.
                  '''
            resval: 0x0
        }
      ]
    },
    { name: "MEM_POWER_UP_READY",
      desc: "Memory Operation Ready Status Register.",
      swaccess: "ro",
      hwaccess: "hwo",
      hwext: "true",
      fields: [
        {
            bits: "0",
            name:"prn",
            desc: '''
                  Power up ready negative
                  When entering normal mode from power mode, PRN is changed from 1 to 0 to
                  notify that power up is completed.'''
        }
      ]
    },
  ],
}
