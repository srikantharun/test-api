// (C) Copyright Axelera AI 2021
// All Rights Reserved
// *** Axelera AI Confidential ***
{ name: "soc_mgmt_reset_gen_csr",
  clocking: [{clock: "clk_i", reset: "rst_ni"}],
  bus_interfaces: [
    { protocol: "tlul", direction: "device" }
  ],
  regwidth: "32",
  addrcap: "0x10000",
  registers: [
    { name: "RST_CFG_AO_RST",
      desc: "Reset configuration for stage `ao_rst`.",
      swaccess: "rw",
      hwaccess: "hro",
      fields: [
        {
          bits: "1:0"
          name: "RST_SRC_MASK",
          desc: "bit 0: Mask watchdog timer (WDT) always-on reset source `wdt_ao_rst`, no effect if WDT reset is configured as `global_rst`. bit 1: Reserved."
          resval: "3"
        },
        {
          bits: "27:16",
          name: "RST_STRETCH",
          desc: "Stretch reset for register `{c['name']}`."
          resval: "10"
        }
      ],
    },
    { name: "RST_SW_AO_RST",
      desc: "Software reset (Active Low) for stage `ao_rst`.",
      swaccess: "rw",
      hwaccess: "hro",
      fields: [
        {
          bits: "0"
          name: "RST_SW",
          desc: "Reset stage `{c['name']}`. (active low)"
          resval: "1"
        }
      ],
    }
    { name: "RST_CFG_DMI_RST",
      desc: "Reset configuration for stage `dmi_rst`.",
      swaccess: "rw",
      hwaccess: "hro",
      fields: [
        {
          bits: "1:0"
          name: "RST_SRC_MASK",
          desc: "bit 0: Mask MBIST reset source `mbist_rst_n`. bit 1: Mask Root of Trust reset source `rot_rst_n`, this reset is triggered via KSE3 JTAG port."
          resval: "0"
        },
        {
          bits: "27:16",
          name: "RST_STRETCH",
          desc: "Stretch reset for register `{c['name']}`."
          resval: "10"
        }
      ],
    },
    { name: "RST_SW_DMI_RST",
      desc: "Software reset (Active Low) for stage `dmi_rst`.",
      swaccess: "rw",
      hwaccess: "hro",
      fields: [
        {
          bits: "0"
          name: "RST_SW",
          desc: "Reset stage `{c['name']}`. (active low)"
          resval: "1"
        }
      ],
    }
    { name: "RST_CFG_GLOBAL_RST",
      desc: "Reset configuration for stage `global_rst`.",
      swaccess: "rw",
      hwaccess: "hro",
      fields: [
        {
          bits: "1:0"
          name: "RST_SRC_MASK",
          desc: "bit 0: Mask debugger global reset source `debug_rst_n`. bit 1: Mask watchdog timer (WDT) global reset source `wdt_global_rst_n`, no effect if WDT reset is configured as `ao_rst`."
          resval: "3"
        },
        {
          bits: "27:16",
          name: "RST_STRETCH",
          desc: "Stretch reset for register `{c['name']}`."
          resval: "10"
        }
      ],
    },
    { name: "RST_SW_GLOBAL_RST",
      desc: "Software reset (Active Low) for stage `global_rst`.",
      swaccess: "rw",
      hwaccess: "hro",
      fields: [
        {
          bits: "0"
          name: "RST_SW",
          desc: "Reset stage `{c['name']}`. (active low)"
          resval: "1"
        }
      ],
    },
    { name: "WDT_RESET_CONFIG",
      desc: "Configuration register for reset triggered by Watchdog Timer's timeout event.",
      swaccess: "rw",
      hwaccess: "hro",
      fields: [
        {
          bits: "0"
          name: "WDT_AO_RESET",
          desc: "When 1: WDT timeout triggers an `ao_rst`. When 0: WDT timeout triggers a `global_rst`."
          resval: "0"
        }
      ],
    }
  ]
}
