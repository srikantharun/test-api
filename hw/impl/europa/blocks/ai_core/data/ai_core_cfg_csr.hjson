// Copyright lowRISC contributors.
// Licensed under the Apache License, Version 2.0, see LICENSE for details.
// SPDX-License-Identifier: Apache-2.0
{ name: "ai_core_cfg_csr",
  clocking: [{clock: "clk_i", reset: "rst_ni"}],
  bus_interfaces: [
    { protocol: "tlul", direction: "device" }
  ],
  regwidth: "32",
  addrcap: "0x1000",
  axi_intf: False
  param_list : [
    {name:"AW", type:"int", default:"16"}
  ]
  registers: [
    { skipto: "0x200" },
    { name: "RESET_VECTOR_LSB",
      desc: "The reset vector for the core. LSB part of it (31..0)",
      swaccess: "rw",
      hwaccess: "hro",
      fields: [
        {
            bits: "31:0",
            name:"reset_vector_lsb",
            desc: '''
                  Reset vector for the AI Core RiscV processor.
                  This will be the address where the core will boot from.'''
        }
      ]
    },
    { name: "RESET_VECTOR_MSB",
      desc: "The reset vector for the core. MSB part of it (40..32)",
      swaccess: "rw",
      hwaccess: "hro",
      fields: [
        {
            bits: "7:0",
            name:"reset_vector_msb",
            desc: '''
                  Reset vector for the AI Core RiscV processor.
                  This will be the address where the core will boot from.'''
        }
      ]
    },
    { name: "IMC_BIST_STATUS",
      desc: "The bist status signals off the IMC.",
      swaccess: "ro",
      hwaccess: "hwo",
      hwext: "true",
      fields: [
        {
            bits: "0",
            name:"imc_bist_busy",
            desc: '''
                  IMC bist is running'''
        },
        {
            bits: "1",
            name:"imc_bist_done",
            desc: '''
                  IMC bist is done'''
        },
        {
            bits: "2",
            name:"imc_bist_pass",
            desc: '''
                  IMC bist passed'''
        }
      ]
    },
  ]
}
