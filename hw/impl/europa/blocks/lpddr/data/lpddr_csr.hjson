// Copyright lowRISC contributors.
// Licensed under the Apache License, Version 2.0, see LICENSE for details.
// SPDX-License-Identifier: Apache-2.0
{ name: "lpddr_csr",
  clocking: [{clock: "clk_i", reset: "rst_ni"}],
  bus_interfaces: [
    { protocol: "tlul", direction: "device" }
  ],
  regwidth: "32",
  addrcap: "0x1000",
  axi_intf: False
  param_list : [
    {name:"AW", type:"int", default:"16"}
  ]
  registers: [
    { skipto: "0x200" }
    { name: "MEM_POWER_MODE_LPDDR",
      desc: "Control Register to select the power mode of the LPDDR internal SRAM memories.",
      swaccess: "rw",
      hwaccess: "hro"
      fields: [
        {
            bits: "0",
            name: "ret",
            desc: '''
                  Retention mode enable, active high
                  When PDE is high and RET are low, the memory operates in the power-down
                  mode. However, when PDE is high and RET is high, you can control the retention
                  voltage of the core by varying VDDCE.
                  '''
            resval: 0x0
        }
        {
            bits: "1",
            name: "pde",
            desc: '''
                  Power down enable, active high
                  During normal SRAM operation, this signal must be low to enable power gates.
                  When high, the retention mode or power-down mode is enable.
                  '''
            resval: 0x0
        }
      ]
    },
    { 
      name: "MEM_POWER_UP_READY_LPDDR",
      desc: "Status Register that indicates the Ready for Operation of the LPDDR memory.",
      swaccess: "ro",
      hwaccess: "hwo",
      hwext: "true",
      fields: [
        {
            bits: "0",
            name:"prn",
            desc: '''
                  Power up ready negative
                  When entering normal mode from power mode, PRN is changed from 1 to 0 to
                  notify that power up is completed.'''
        }
      ]
    },
    { 
      name: "HIF_MODE_READ",
      desc: "This registers stores the data value of the latest hif_mrr_data transaction. Updated automatically van hif_mrr_data_valid is asserted.",
      swaccess: "ro",
      hwaccess: "hwo",
      hwext: "true",
      fields: [
        {
            bits: "31:0",
            name:"value",
            desc: '''
                  Latest hif_mrr_data.
                  '''
        }
      ]
    },
    {
      name: "CONFIG_LPDDR"
      desc: "Register generic config settings for the LPDDR."
      swaccess : "rw"
      hwaccess : "hro"
      fields: 
      [
        {
          bits: "0",
          name: "dis_regs_ecc_syndrome",
          desc: '''
                Signal used to hide the value of ECCCSYN* and ECCUSYN* registers, e.g. for security purposes. When this value is set to 1, reading registers ECCCSYN*/ECCUSYN* returns value 0 always, otherwise it returns appropriate value.
                '''
        },
        {
          bits: "8",
          name: "awurgent",
          desc: '''
                AXI Write Urgent. Sideband signal to indicate a write urgent transaction. When asserted, if wr_port_urgent_en register is set, causes the port arbiter to switch immediately to write. It can be asserted anytime, and is not associated to any particular command
                '''
        },
        {
          bits: "16",
          name: "arurgent",
          desc: '''
                AXI read Urgent. Sideband signal to indicate a read urgent transaction. When asserted, if rd_port_urgent_en register is set, causes the port arbiter to switch immediately to read. It can be asserted anytime, and is not associated to any particular command
                '''
        },
      ]
    },
    {
      name: "AXI_LOW_POWER_CONTROL"
      desc: "Register controlling the AXI hardware lower power interface controller"
      swaccess : "rw"
      hwaccess : "hro"
      fields: 
      [
        {
          bits: "0",
          name: "LP_EN",
          resval: 0,
          desc: '''
                Enable the AXI hardware low power controller. The controller will automatically gate the AXI clock when the interface becomes idle.
                '''
        },
        {
          bits: "23:8",
          name: "IDLE_DELAY",
          resval: 10,
          desc: '''
                Time in cycles of LPDDR_CLK that the low power interface has to indicate that the AXI interface is idle before actually requesting the low power state and gating the clock.
                '''
        },
      ]
    },
    {
      name: "DDRC_LOW_POWER_CONTROL"
      desc: "Register controlling the DDRC hardware lower power interface controller"
      swaccess : "rw"
      hwaccess : "hro"
      fields: 
      [
        {
          bits: "0",
          name: "LP_EN",
          resval: 0,
          desc: '''
                Enable the DDRC hardware low power controller. The controller will automatically gate the DDRC core clock when the controller becomes idle.
                '''
        },
        {
          bits: "23:8",
          name: "IDLE_DELAY",
          resval: 10,
          desc: '''
                Time in cycles of LPDDR_CLK that the low power interface has to indicate that the controller is idle before actually requesting the low power state and gating the clock.
                '''
        },
      ]
    },
    {
      name: "DEBUG_CAM_SCHEDULE_LPDDR"
      desc: "Register with debug information of the LPDDR CAM schedule."
      swaccess : "ro"
      hwaccess : "hwo"
      fields: 
      [
        {
          bits: "0",
          name: "perf_rank",
          desc: '''
                Gives the rank number for every scheduled command in DDRC through CAM path.
                '''
        },
        {
          bits: "10:8",
          name: "perf_bank",
          desc: '''
                Gives the bank number for every scheduled command in DDRC through CAM path.
                '''
        },
        {
          bits: "17:16",
          name: "perf_bank_group",
          desc: '''
                Gives the bank group number for every scheduled command in DDRC through CAM path.
                '''
        },
      ]
    },
    {
      name: "DEBUG_CAM_CREDIT_COUNT_LPDDR"
      desc: "Register with debug information of the LPDDR CAM schedule."
      swaccess : "ro"
      hwaccess : "hwo"
      fields: 
      [
        {
          bits: "6:0",
          name: "hpr_credit_cnt",
          desc: '''
                Indicates the number of available High priority read CAM slots (free positions). Each slots holds a DRAM burst. Value is decremented/incremented as the commands flow in out of the read CAM (HPR store).
                '''
        },
        {
          bits: "14:8",
          name: "lpr_credit_cnt",
          desc: '''
                Indicates the number of available Low priority read CAM slots (free positions). Each slots holds a DRAM burst. Value is decremented/incremented as the commands flow in out of the read CAM (LPR store).
                '''
        },
        {
          bits: "22:16",
          name: "wr_credit_cnt",
          desc: '''
                Indicates the number of available write CAM slots (free positions). Each slots holds a DRAM burst. Value is decremented/incremented as the commands flow in out of the write CAM.
                '''
        },
        {
          bits: "31:24",
          name: "wrecc_credit_cnt",
          desc: '''
                Indicates the number of available write ECC CAM slots (free positions). Each slots holds a DRAM burst. Value is decremented/incremented as the commands flow in out of the write ECC CAM.
                '''
        },
      ]
    },
    {
      name: "DEBUG_ADDRESS_FIFOS_LPDDR"
      desc: "Register with debug information about the number of positions used in each of the address fifos in the LPDDR"
      swaccess : "ro"
      hwaccess : "hwo"
      fields: 
      [
        {
          bits: "5:0",
          name: "raqb_wcount",
          desc: '''
                Number of used positions in the Blue Read address FIFO.
                '''
        },
        {
          bits: "13:8",
          name: "raqr_wcount",
          desc: '''
                Number of used positions in the Red Read address FIFO
                '''
        },
        {
          bits: "21:16",
          name: "waq_wcount",
          desc: '''
                Number of used positions in the Write address FIFO.
                '''
        },
      ]
    },
    {
      name: "DEBUG_PHY_STATUS"
      desc: "Register with debug information of the LPDDR PHY status."
      swaccess : "ro"
      hwaccess : "hwo"
      hwext: "true",
      fields: 
      [
        {
          bits: "0",
          name: "pll_lock",
          desc: '''
                PLL lock signal of the internal PHY pll. Can also be read through the PHY APB registers.
                '''
        },
        {
          bits: "8",
          name: "pmu_busy",
          desc: '''
                Busy flag of the PHY management unit. Can also be access through the PHY APB registers.
                '''
        },
        {
          bits: "22:16",
          name: "wr_credit_cnt",
          desc: '''
                Indicates the number of available write CAM slots (free positions). Each slots holds a DRAM burst. Value is decremented/incremented as the commands flow in out of the write CAM.
                '''
        },
        {
          bits: "31:24",
          name: "wrecc_credit_cnt",
          desc: '''
                Indicates the number of available write ECC CAM slots (free positions). Each slots holds a DRAM burst. Value is decremented/incremented as the commands flow in out of the write ECC CAM.
                '''
        },
      ]
    },
    {
      name: "LPDDR_PERF_COUNT_ENABLES_0"
      desc: "Enable register for performance counters, each bit enables a specific counter. Part 1"
      swaccess : "rw"
      hwaccess : "hro"
      fields: 
      [
        {
          bits: "0",
          name: "perf_dfi_rd_data_cycles",
          desc: '''
                Enable bit to enable performance log counter for perf_dfi_rd_data_cycles.
                '''
        },
        {
          bits: "1",
          name: "perf_dfi_wr_data_cycles",
          desc: '''
                Enable bit to enable performance log counter for perf_dfi_wr_data_cycles.
                '''
        },
        {
          bits: "2",
          name: "perf_hif_hi_pri_rd",
          desc: '''
                Enable bit to enable performance log counter for perf_hif_hi_pri_rd.
                '''
        },
        {
          bits: "3",
          name: "perf_hif_rd",
          desc: '''
                Enable bit to enable performance log counter for perf_hif_rd.
                '''
        },
        {
          bits: "4",
          name: "perf_hif_rd_or_wr",
          desc: '''
                Enable bit to enable performance log counter for perf_hif_rd_or_wr.
                '''
        },
        {
          bits: "5",
          name: "perf_hif_rmw",
          desc: '''
                Enable bit to enable performance log counter for perf_hif_rmw.
                '''
        },
        {
          bits: "6",
          name: "perf_hif_wr",
          desc: '''
                Enable bit to enable performance log counter for perf_hif_wr.
                '''
        },
        {
          bits: "7",
          name: "perf_hpr_req_with_nocredit",
          desc: '''
                Enable bit to enable performance log counter for perf_hpr_req_with_nocredit.
                '''
        },
        {
          bits: "8",
          name: "perf_hpr_xact_when_critical",
          desc: '''
                Enable bit to enable performance log counter for perf_hpr_xact_when_critical.
                '''
        },
        {
          bits: "9",
          name: "perf_ie_blk_hazard",
          desc: '''
                Enable bit to enable performance log counter for perf_ie_blk_hazard.
                '''
        },
        {
          bits: "10",
          name: "perf_lpr_req_with_nocredit",
          desc: '''
                Enable bit to enable performance log counter for perf_lpr_req_with_nocredit.
                '''
        },
        {
          bits: "11",
          name: "perf_lpr_xact_when_critical",
          desc: '''
                Enable bit to enable performance log counter for perf_lpr_xact_when_critical.
                '''
        },
        {
          bits: "12",
          name: "perf_op_is_activate",
          desc: '''
                Enable bit to enable performance log counter for perf_op_is_activate.
                '''
        },
        {
          bits: "13",
          name: "perf_op_is_cas",
          desc: '''
                Enable bit to enable performance log counter for perf_op_is_cas.
                '''
        },
        {
          bits: "14",
          name: "perf_op_is_cas_wck_sus",
          desc: '''
                Enable bit to enable performance log counter for perf_op_is_cas_wck_sus.
                '''
        },
        {
          bits: "15",
          name: "perf_op_is_cas_ws",
          desc: '''
                Enable bit to enable performance log counter for perf_op_is_cas_ws.
                '''
        },
        {
          bits: "16",
          name: "perf_op_is_cas_ws_off",
          desc: '''
                Enable bit to enable performance log counter for perf_op_is_cas_ws_off.
                '''
        },
        {
          bits: "17",
          name: "perf_op_is_crit_ref",
          desc: '''
                Enable bit to enable performance log counter for perf_op_is_crit_ref.
                '''
        },
        {
          bits: "18",
          name: "perf_op_is_dqsosc_mpc",
          desc: '''
                Enable bit to enable performance log counter for perf_op_is_dqsosc_mpc.
                '''
        },
        {
          bits: "19",
          name: "perf_op_is_dqsosc_mrr",
          desc: '''
                Enable bit to enable performance log counter for perf_op_is_dqsosc_mrr.
                '''
        },
        {
          bits: "20",
          name: "perf_op_is_enter_dsm",
          desc: '''
                Enable bit to enable performance log counter for perf_op_is_enter_dsm.
                '''
        },
        {
          bits: "21",
          name: "perf_op_is_enter_powerdown_rank_0",
          desc: '''
                Enable bit to enable performance log counter for perf_op_is_enter_powerdown_rank_0.
                '''
        },
        {
          bits: "22",
          name: "perf_op_is_enter_powerdown_rank_1",
          desc: '''
                Enable bit to enable performance log counter for perf_op_is_enter_powerdown_rank_1.
                '''
        },
        {
          bits: "23",
          name: "perf_op_is_enter_selfref_rank_0",
          desc: '''
                Enable bit to enable performance log counter for perf_op_is_enter_selfref_rank_0.
                '''
        },
        {
          bits: "24",
          name: "perf_op_is_enter_selfref_rank_1",
          desc: '''
                Enable bit to enable performance log counter for perf_op_is_enter_selfref_rank_1.
                '''
        },
        {
          bits: "25",
          name: "perf_op_is_load_mode",
          desc: '''
                Enable bit to enable performance log counter for perf_op_is_load_mode.
                '''
        },
        {
          bits: "26",
          name: "perf_op_is_mwr",
          desc: '''
                Enable bit to enable performance log counter for perf_op_is_mwr.
                '''
        },
        {
          bits: "27",
          name: "perf_op_is_precharge",
          desc: '''
                Enable bit to enable performance log counter for perf_op_is_precharge.
                '''
        },
        {
          bits: "28",
          name: "perf_op_is_rd",
          desc: '''
                Enable bit to enable performance log counter for perf_op_is_rd.
                '''
        },
        {
          bits: "29",
          name: "perf_op_is_rd_activate",
          desc: '''
                Enable bit to enable performance log counter for perf_op_is_rd_activate.
                '''
        },
        {
          bits: "30",
          name: "perf_op_is_rd_or_wr",
          desc: '''
                Enable bit to enable performance log counter for perf_op_is_rd_or_wr.
                '''
        },
        {
          bits: "31",
          name: "perf_op_is_refresh",
          desc: '''
                Enable bit to enable performance log counter for perf_op_is_refresh.
                '''
        }
      ]
    },
    {
      name: "LPDDR_PERF_COUNT_ENABLES_1"
      desc: "Enable register for performance counters, each bit enables a specific counter. Part 2"
      swaccess : "rw"
      hwaccess : "hro"
      fields:
      [
        {
          bits: "0",
          name: "perf_op_is_rfm",
          desc: '''
                Enable bit to enable performance log counter for perf_op_is_rfm.
                '''
        },
        {
          bits: "1",
          name: "perf_op_is_spec_ref",
          desc: '''
                Enable bit to enable performance log counter for perf_op_is_spec_ref.
                '''
        },
        {
          bits: "2",
          name: "perf_op_is_tcr_mrr",
          desc: '''
                Enable bit to enable performance log counter for perf_op_is_tcr_mrr.
                '''
        },
        {
          bits: "3",
          name: "perf_op_is_wr",
          desc: '''
                Enable bit to enable performance log counter for perf_op_is_wr.
                '''
        },
        {
          bits: "4",
          name: "perf_op_is_zqlatch",
          desc: '''
                Enable bit to enable performance log counter for perf_op_is_zqlatch.
                '''
        },
        {
          bits: "5",
          name: "perf_op_is_zqstart",
          desc: '''
                Enable bit to enable performance log counter for perf_op_is_zqstart.
                '''
        },
        {
          bits: "6",
          name: "perf_precharge_for_other",
          desc: '''
                Enable bit to enable performance log counter for perf_precharge_for_other.
                '''
        },
        {
          bits: "7",
          name: "perf_precharge_for_rdwr",
          desc: '''
                Enable bit to enable performance log counter for perf_precharge_for_rdwr.
                '''
        },
        {
          bits: "8",
          name: "perf_raw_hazard",
          desc: '''
                Enable bit to enable performance log counter for perf_raw_hazard.
                '''
        },
        {
          bits: "9",
          name: "perf_rdwr_transitions",
          desc: '''
                Enable bit to enable performance log counter for perf_rdwr_transitions.
                '''
        },
        {
          bits: "10",
          name: "perf_selfref_mode_rank_0",
          desc: '''
                Enable bit to enable performance log counter for perf_selfref_mode_rank_0.
                '''
        },
        {
          bits: "11",
          name: "perf_selfref_mode_rank_1",
          desc: '''
                Enable bit to enable performance log counter for perf_selfref_mode_rank_1.
                '''
        },
        {
          bits: "12",
          name: "perf_visible_window_limit_reached_rd",
          desc: '''
                Enable bit to enable performance log counter for perf_visible_window_limit_reached_rd.
                '''
        },
        {
          bits: "13",
          name: "perf_visible_window_limit_reached_wr",
          desc: '''
                Enable bit to enable performance log counter for perf_visible_window_limit_reached_wr.
                '''
        },
        {
          bits: "14",
          name: "perf_war_hazard",
          desc: '''
                Enable bit to enable performance log counter for perf_war_hazard.
                '''
        },
        {
          bits: "15",
          name: "perf_waw_hazard",
          desc: '''
                Enable bit to enable performance log counter for perf_waw_hazard.
                '''
        },
        {
          bits: "16",
          name: "perf_wr_xact_when_critical",
          desc: '''
                Enable bit to enable performance log counter for perf_wr_xact_when_critical.
                '''
        },
        {
          bits: "17",
          name: "perf_write_combine",
          desc: '''
                Enable bit to enable performance log counter for perf_write_combine.
                '''
        },
        {
          bits: "18",
          name: "perf_write_combine_noecc",
          desc: '''
                Enable bit to enable performance log counter for perf_write_combine_noecc.
                '''
        },
        {
          bits: "19",
          name: "perf_write_combine_wrecc",
          desc: '''
                Enable bit to enable performance log counter for perf_write_combine_wrecc.
                '''
        },
        {
          bits: "20",
          name: "raq_split",
          desc: '''
                Enable bit to enable performance log counter for raq_split.
                '''
        },
        {
          bits: "21",
          name: "raqb_pop",
          desc: '''
                Enable bit to enable performance log counter for raqb_pop.
                '''
        },
        {
          bits: "22",
          name: "raqb_push",
          desc: '''
                Enable bit to enable performance log counter for raqb_push.
                '''
        },
        {
          bits: "23",
          name: "raqr_pop",
          desc: '''
                Enable bit to enable performance log counter for raqr_pop.
                '''
        },
        {
          bits: "24",
          name: "raqr_push",
          desc: '''
                Enable bit to enable performance log counter for raqr_push.
                '''
        },
        {
          bits: "25",
          name: "waq_pop",
          desc: '''
                Enable bit to enable performance log counter for waq_pop.
                '''
        },
        {
          bits: "26",
          name: "waq_push",
          desc: '''
                Enable bit to enable performance log counter for waq_push.
                '''
        },
        {
          bits: "27",
          name: "waq_split",
          desc: '''
                Enable bit to enable performance log counter for waq_split.
                '''
        }
      ]
    },
    {
      name: "LPDDR_PERF_COUNT_CONFIG"
      desc: "Configuration settings for the LPDDR performance counters."
      swaccess : "rw"
      hwaccess : "hro"
      fields: 
      [
        {
          bits: "0",
          name: "lpddr_perf_clear_on_read",
          desc: '''
                When set to 1, reading a perf counter value resets that specific counter to 0.
                '''
        },
        {
          bits: "8",
          name: "lpddr_perf_clear_all",
          desc: '''
                When set to 1, all perf counters are kept in flushing state, when releasing to 0, all counters start with 0 value internally.
                '''
        },
      ]
    },
    { 
      name: "LPDDR_PERF_DFI_RD_DATA_CYCLES_COUNT",
      desc : "Performance counting register that indicates the perf_dfi_rd_data_cycles count since the previous read (clear on read).",
      swaccess : "rc",
      hwaccess : "hrw",
      hwext: "true",
      hwqe : "true",
      hwre : "true",
      fields : [
        {
          bits: "31:0"
          name: "counter_value"
          desc: '''
                Counter value of perf_dfi_rd_data_cycles performance counter. Clear automatically on read when LPDDR_PERF_CLEAR_ON_READ is high.
                '''
        }
      ]
    },
    { 
      name: "LPDDR_PERF_DFI_WR_DATA_CYCLES_COUNT",
      desc : "Performance counting register that indicates the perf_dfi_wr_data_cycles count since the previous read (clear on read).",
      swaccess : "rc",
      hwaccess : "hrw",
      hwext: "true",
      hwqe : "true",
      hwre : "true",
      fields : [
        {
          bits: "31:0"
          name: "counter_value"
          desc: '''
                Counter value of perf_dfi_wr_data_cycles performance counter. Clear automatically on read when LPDDR_PERF_CLEAR_ON_READ is high.
                '''
        }
      ]
    },
    { 
      name: "LPDDR_PERF_HIF_HI_PRI_RD_COUNT",
      desc : "Performance counting register that indicates the perf_hif_hi_pri_rd count since the previous read (clear on read).",
      swaccess : "rc",
      hwaccess : "hrw",
      hwext: "true",
      hwqe : "true",
      hwre : "true",
      fields : [
        {
          bits: "31:0"
          name: "counter_value"
          desc: '''
                Counter value of perf_hif_hi_pri_rd performance counter. Clear automatically on read when LPDDR_PERF_CLEAR_ON_READ is high.
                '''
        }
      ]
    },
    { 
      name: "LPDDR_PERF_HIF_RD_COUNT",
      desc : "Performance counting register that indicates the perf_hif_rd count since the previous read (clear on read).",
      swaccess : "rc",
      hwaccess : "hrw",
      hwext: "true",
      hwqe : "true",
      hwre : "true",
      fields : [
        {
          bits: "31:0"
          name: "counter_value"
          desc: '''
                Counter value of perf_hif_rd performance counter. Clear automatically on read when LPDDR_PERF_CLEAR_ON_READ is high.
                '''
        }
      ]
    },
    { 
      name: "LPDDR_PERF_HIF_RD_OR_WR_COUNT",
      desc : "Performance counting register that indicates the perf_hif_rd_or_wr count since the previous read (clear on read).",
      swaccess : "rc",
      hwaccess : "hrw",
      hwext: "true",
      hwqe : "true",
      hwre : "true",
      fields : [
        {
          bits: "31:0"
          name: "counter_value"
          desc: '''
                Counter value of perf_hif_rd_or_wr performance counter. Clear automatically on read when LPDDR_PERF_CLEAR_ON_READ is high.
                '''
        }
      ]
    },
    { 
      name: "LPDDR_PERF_HIF_RMW_COUNT",
      desc : "Performance counting register that indicates the perf_hif_rmw count since the previous read (clear on read).",
      swaccess : "rc",
      hwaccess : "hrw",
      hwext: "true",
      hwqe : "true",
      hwre : "true",
      fields : [
        {
          bits: "31:0"
          name: "counter_value"
          desc: '''
                Counter value of perf_hif_rmw performance counter. Clear automatically on read when LPDDR_PERF_CLEAR_ON_READ is high.
                '''
        }
      ]
    },
    { 
      name: "LPDDR_PERF_HIF_WR_COUNT",
      desc : "Performance counting register that indicates the perf_hif_wr count since the previous read (clear on read).",
      swaccess : "rc",
      hwaccess : "hrw",
      hwext: "true",
      hwqe : "true",
      hwre : "true",
      fields : [
        {
          bits: "31:0"
          name: "counter_value"
          desc: '''
                Counter value of perf_hif_wr performance counter. Clear automatically on read when LPDDR_PERF_CLEAR_ON_READ is high.
                '''
        }
      ]
    },
    { 
      name: "LPDDR_PERF_HPR_REQ_WITH_NOCREDIT_COUNT",
      desc : "Performance counting register that indicates the perf_hpr_req_with_nocredit count since the previous read (clear on read).",
      swaccess : "rc",
      hwaccess : "hrw",
      hwext: "true",
      hwqe : "true",
      hwre : "true",
      fields : [
        {
          bits: "31:0"
          name: "counter_value"
          desc: '''
                Counter value of perf_hpr_req_with_nocredit performance counter. Clear automatically on read when LPDDR_PERF_CLEAR_ON_READ is high.
                '''
        }
      ]
    },
    { 
      name: "LPDDR_PERF_HPR_XACT_WHEN_CRITICAL_COUNT",
      desc : "Performance counting register that indicates the perf_hpr_xact_when_critical count since the previous read (clear on read).",
      swaccess : "rc",
      hwaccess : "hrw",
      hwext: "true",
      hwqe : "true",
      hwre : "true",
      fields : [
        {
          bits: "31:0"
          name: "counter_value"
          desc: '''
                Counter value of perf_hpr_xact_when_critical performance counter. Clear automatically on read when LPDDR_PERF_CLEAR_ON_READ is high.
                '''
        }
      ]
    },
    { 
      name: "LPDDR_PERF_IE_BLK_HAZARD_COUNT",
      desc : "Performance counting register that indicates the perf_ie_blk_hazard count since the previous read (clear on read).",
      swaccess : "rc",
      hwaccess : "hrw",
      hwext: "true",
      hwqe : "true",
      hwre : "true",
      fields : [
        {
          bits: "31:0"
          name: "counter_value"
          desc: '''
                Counter value of perf_ie_blk_hazard performance counter. Clear automatically on read when LPDDR_PERF_CLEAR_ON_READ is high.
                '''
        }
      ]
    },
    { 
      name: "LPDDR_PERF_LPR_REQ_WITH_NOCREDIT_COUNT",
      desc : "Performance counting register that indicates the perf_lpr_req_with_nocredit count since the previous read (clear on read).",
      swaccess : "rc",
      hwaccess : "hrw",
      hwext: "true",
      hwqe : "true",
      hwre : "true",
      fields : [
        {
          bits: "31:0"
          name: "counter_value"
          desc: '''
                Counter value of perf_lpr_req_with_nocredit performance counter. Clear automatically on read when LPDDR_PERF_CLEAR_ON_READ is high.
                '''
        }
      ]
    },
    { 
      name: "LPDDR_PERF_LPR_XACT_WHEN_CRITICAL_COUNT",
      desc : "Performance counting register that indicates the perf_lpr_xact_when_critical count since the previous read (clear on read).",
      swaccess : "rc",
      hwaccess : "hrw",
      hwext: "true",
      hwqe : "true",
      hwre : "true",
      fields : [
        {
          bits: "31:0"
          name: "counter_value"
          desc: '''
                Counter value of perf_lpr_xact_when_critical performance counter. Clear automatically on read when LPDDR_PERF_CLEAR_ON_READ is high.
                '''
        }
      ]
    },
    { 
      name: "LPDDR_PERF_OP_IS_ACTIVATE_COUNT",
      desc : "Performance counting register that indicates the perf_op_is_activate count since the previous read (clear on read).",
      swaccess : "rc",
      hwaccess : "hrw",
      hwext: "true",
      hwqe : "true",
      hwre : "true",
      fields : [
        {
          bits: "31:0"
          name: "counter_value"
          desc: '''
                Counter value of perf_op_is_activate performance counter. Clear automatically on read when LPDDR_PERF_CLEAR_ON_READ is high.
                '''
        }
      ]
    },
    { 
      name: "LPDDR_PERF_OP_IS_CAS_COUNT",
      desc : "Performance counting register that indicates the perf_op_is_cas count since the previous read (clear on read).",
      swaccess : "rc",
      hwaccess : "hrw",
      hwext: "true",
      hwqe : "true",
      hwre : "true",
      fields : [
        {
          bits: "31:0"
          name: "counter_value"
          desc: '''
                Counter value of perf_op_is_cas performance counter. Clear automatically on read when LPDDR_PERF_CLEAR_ON_READ is high.
                '''
        }
      ]
    },
    { 
      name: "LPDDR_PERF_OP_IS_CAS_WCK_SUS_COUNT",
      desc : "Performance counting register that indicates the perf_op_is_cas_wck_sus count since the previous read (clear on read).",
      swaccess : "rc",
      hwaccess : "hrw",
      hwext: "true",
      hwqe : "true",
      hwre : "true",
      fields : [
        {
          bits: "31:0"
          name: "counter_value"
          desc: '''
                Counter value of perf_op_is_cas_wck_sus performance counter. Clear automatically on read when LPDDR_PERF_CLEAR_ON_READ is high.
                '''
        }
      ]
    },
    { 
      name: "LPDDR_PERF_OP_IS_CAS_WS_COUNT",
      desc : "Performance counting register that indicates the perf_op_is_cas_ws count since the previous read (clear on read).",
      swaccess : "rc",
      hwaccess : "hrw",
      hwext: "true",
      hwqe : "true",
      hwre : "true",
      fields : [
        {
          bits: "31:0"
          name: "counter_value"
          desc: '''
                Counter value of perf_op_is_cas_ws performance counter. Clear automatically on read when LPDDR_PERF_CLEAR_ON_READ is high.
                '''
        }
      ]
    },
    { 
      name: "LPDDR_PERF_OP_IS_CAS_WS_OFF_COUNT",
      desc : "Performance counting register that indicates the perf_op_is_cas_ws_off count since the previous read (clear on read).",
      swaccess : "rc",
      hwaccess : "hrw",
      hwext: "true",
      hwqe : "true",
      hwre : "true",
      fields : [
        {
          bits: "31:0"
          name: "counter_value"
          desc: '''
                Counter value of perf_op_is_cas_ws_off performance counter. Clear automatically on read when LPDDR_PERF_CLEAR_ON_READ is high.
                '''
        }
      ]
    },
    { 
      name: "LPDDR_PERF_OP_IS_CRIT_REF_COUNT",
      desc : "Performance counting register that indicates the perf_op_is_crit_ref count since the previous read (clear on read).",
      swaccess : "rc",
      hwaccess : "hrw",
      hwext: "true",
      hwqe : "true",
      hwre : "true",
      fields : [
        {
          bits: "31:0"
          name: "counter_value"
          desc: '''
                Counter value of perf_op_is_crit_ref performance counter. Clear automatically on read when LPDDR_PERF_CLEAR_ON_READ is high.
                '''
        }
      ]
    },
    { 
      name: "LPDDR_PERF_OP_IS_DQSOSC_MPC_COUNT",
      desc : "Performance counting register that indicates the perf_op_is_dqsosc_mpc count since the previous read (clear on read).",
      swaccess : "rc",
      hwaccess : "hrw",
      hwext: "true",
      hwqe : "true",
      hwre : "true",
      fields : [
        {
          bits: "31:0"
          name: "counter_value"
          desc: '''
                Counter value of perf_op_is_dqsosc_mpc performance counter. Clear automatically on read when LPDDR_PERF_CLEAR_ON_READ is high.
                '''
        }
      ]
    },
    { 
      name: "LPDDR_PERF_OP_IS_DQSOSC_MRR_COUNT",
      desc : "Performance counting register that indicates the perf_op_is_dqsosc_mrr count since the previous read (clear on read).",
      swaccess : "rc",
      hwaccess : "hrw",
      hwext: "true",
      hwqe : "true",
      hwre : "true",
      fields : [
        {
          bits: "31:0"
          name: "counter_value"
          desc: '''
                Counter value of perf_op_is_dqsosc_mrr performance counter. Clear automatically on read when LPDDR_PERF_CLEAR_ON_READ is high.
                '''
        }
      ]
    },
    { 
      name: "LPDDR_PERF_OP_IS_ENTER_DSM_COUNT",
      desc : "Performance counting register that indicates the perf_op_is_enter_dsm count since the previous read (clear on read).",
      swaccess : "rc",
      hwaccess : "hrw",
      hwext: "true",
      hwqe : "true",
      hwre : "true",
      fields : [
        {
          bits: "31:0"
          name: "counter_value"
          desc: '''
                Counter value of perf_op_is_enter_dsm performance counter. Clear automatically on read when LPDDR_PERF_CLEAR_ON_READ is high.
                '''
        }
      ]
    },
    { 
      name: "LPDDR_PERF_OP_IS_ENTER_POWERDOWN_RANK_0_COUNT",
      desc : "Performance counting register that indicates the perf_op_is_enter_powerdown_rank_0 count since the previous read (clear on read).",
      swaccess : "rc",
      hwaccess : "hrw",
      hwext: "true",
      hwqe : "true",
      hwre : "true",
      fields : [
        {
          bits: "31:0"
          name: "counter_value"
          desc: '''
                Counter value of perf_op_is_enter_powerdown_rank_0 performance counter. Clear automatically on read when LPDDR_PERF_CLEAR_ON_READ is high.
                '''
        }
      ]
    },
    { 
      name: "LPDDR_PERF_OP_IS_ENTER_POWERDOWN_RANK_1_COUNT",
      desc : "Performance counting register that indicates the perf_op_is_enter_powerdown_rank_1 count since the previous read (clear on read).",
      swaccess : "rc",
      hwaccess : "hrw",
      hwext: "true",
      hwqe : "true",
      hwre : "true",
      fields : [
        {
          bits: "31:0"
          name: "counter_value"
          desc: '''
                Counter value of perf_op_is_enter_powerdown_rank_1 performance counter. Clear automatically on read when LPDDR_PERF_CLEAR_ON_READ is high.
                '''
        }
      ]
    },
    { 
      name: "LPDDR_PERF_OP_IS_ENTER_SELFREF_RANK_0_COUNT",
      desc : "Performance counting register that indicates the perf_op_is_enter_selfref_rank_0 count since the previous read (clear on read).",
      swaccess : "rc",
      hwaccess : "hrw",
      hwext: "true",
      hwqe : "true",
      hwre : "true",
      fields : [
        {
          bits: "31:0"
          name: "counter_value"
          desc: '''
                Counter value of perf_op_is_enter_selfref_rank_0 performance counter. Clear automatically on read when LPDDR_PERF_CLEAR_ON_READ is high.
                '''
        }
      ]
    },
    { 
      name: "LPDDR_PERF_OP_IS_ENTER_SELFREF_RANK_1_COUNT",
      desc : "Performance counting register that indicates the perf_op_is_enter_selfref_rank_1 count since the previous read (clear on read).",
      swaccess : "rc",
      hwaccess : "hrw",
      hwext: "true",
      hwqe : "true",
      hwre : "true",
      fields : [
        {
          bits: "31:0"
          name: "counter_value"
          desc: '''
                Counter value of perf_op_is_enter_selfref_rank_1 performance counter. Clear automatically on read when LPDDR_PERF_CLEAR_ON_READ is high.
                '''
        }
      ]
    },
    { 
      name: "LPDDR_PERF_OP_IS_LOAD_MODE_COUNT",
      desc : "Performance counting register that indicates the perf_op_is_load_mode count since the previous read (clear on read).",
      swaccess : "rc",
      hwaccess : "hrw",
      hwext: "true",
      hwqe : "true",
      hwre : "true",
      fields : [
        {
          bits: "31:0"
          name: "counter_value"
          desc: '''
                Counter value of perf_op_is_load_mode performance counter. Clear automatically on read when LPDDR_PERF_CLEAR_ON_READ is high.
                '''
        }
      ]
    },
    { 
      name: "LPDDR_PERF_OP_IS_MWR_COUNT",
      desc : "Performance counting register that indicates the perf_op_is_mwr count since the previous read (clear on read).",
      swaccess : "rc",
      hwaccess : "hrw",
      hwext: "true",
      hwqe : "true",
      hwre : "true",
      fields : [
        {
          bits: "31:0"
          name: "counter_value"
          desc: '''
                Counter value of perf_op_is_mwr performance counter. Clear automatically on read when LPDDR_PERF_CLEAR_ON_READ is high.
                '''
        }
      ]
    },
    { 
      name: "LPDDR_PERF_OP_IS_PRECHARGE_COUNT",
      desc : "Performance counting register that indicates the perf_op_is_precharge count since the previous read (clear on read).",
      swaccess : "rc",
      hwaccess : "hrw",
      hwext: "true",
      hwqe : "true",
      hwre : "true",
      fields : [
        {
          bits: "31:0"
          name: "counter_value"
          desc: '''
                Counter value of perf_op_is_precharge performance counter. Clear automatically on read when LPDDR_PERF_CLEAR_ON_READ is high.
                '''
        }
      ]
    },
    { 
      name: "LPDDR_PERF_OP_IS_RD_COUNT",
      desc : "Performance counting register that indicates the perf_op_is_rd count since the previous read (clear on read).",
      swaccess : "rc",
      hwaccess : "hrw",
      hwext: "true",
      hwqe : "true",
      hwre : "true",
      fields : [
        {
          bits: "31:0"
          name: "counter_value"
          desc: '''
                Counter value of perf_op_is_rd performance counter. Clear automatically on read when LPDDR_PERF_CLEAR_ON_READ is high.
                '''
        }
      ]
    },
    { 
      name: "LPDDR_PERF_OP_IS_RD_ACTIVATE_COUNT",
      desc : "Performance counting register that indicates the perf_op_is_rd_activate count since the previous read (clear on read).",
      swaccess : "rc",
      hwaccess : "hrw",
      hwext: "true",
      hwqe : "true",
      hwre : "true",
      fields : [
        {
          bits: "31:0"
          name: "counter_value"
          desc: '''
                Counter value of perf_op_is_rd_activate performance counter. Clear automatically on read when LPDDR_PERF_CLEAR_ON_READ is high.
                '''
        }
      ]
    },
    { 
      name: "LPDDR_PERF_OP_IS_RD_OR_WR_COUNT",
      desc : "Performance counting register that indicates the perf_op_is_rd_or_wr count since the previous read (clear on read).",
      swaccess : "rc",
      hwaccess : "hrw",
      hwext: "true",
      hwqe : "true",
      hwre : "true",
      fields : [
        {
          bits: "31:0"
          name: "counter_value"
          desc: '''
                Counter value of perf_op_is_rd_or_wr performance counter. Clear automatically on read when LPDDR_PERF_CLEAR_ON_READ is high.
                '''
        }
      ]
    },
    { 
      name: "LPDDR_PERF_OP_IS_REFRESH_COUNT",
      desc : "Performance counting register that indicates the perf_op_is_refresh count since the previous read (clear on read).",
      swaccess : "rc",
      hwaccess : "hrw",
      hwext: "true",
      hwqe : "true",
      hwre : "true",
      fields : [
        {
          bits: "31:0"
          name: "counter_value"
          desc: '''
                Counter value of perf_op_is_refresh performance counter. Clear automatically on read when LPDDR_PERF_CLEAR_ON_READ is high.
                '''
        }
      ]
    },
    { 
      name: "LPDDR_PERF_OP_IS_RFM_COUNT",
      desc : "Performance counting register that indicates the perf_op_is_rfm count since the previous read (clear on read).",
      swaccess : "rc",
      hwaccess : "hrw",
      hwext: "true",
      hwqe : "true",
      hwre : "true",
      fields : [
        {
          bits: "31:0"
          name: "counter_value"
          desc: '''
                Counter value of perf_op_is_rfm performance counter. Clear automatically on read when LPDDR_PERF_CLEAR_ON_READ is high.
                '''
        }
      ]
    },
    { 
      name: "LPDDR_PERF_OP_IS_SPEC_REF_COUNT",
      desc : "Performance counting register that indicates the perf_op_is_spec_ref count since the previous read (clear on read).",
      swaccess : "rc",
      hwaccess : "hrw",
      hwext: "true",
      hwqe : "true",
      hwre : "true",
      fields : [
        {
          bits: "31:0"
          name: "counter_value"
          desc: '''
                Counter value of perf_op_is_spec_ref performance counter. Clear automatically on read when LPDDR_PERF_CLEAR_ON_READ is high.
                '''
        }
      ]
    },
    { 
      name: "LPDDR_PERF_OP_IS_TCR_MRR_COUNT",
      desc : "Performance counting register that indicates the perf_op_is_tcr_mrr count since the previous read (clear on read).",
      swaccess : "rc",
      hwaccess : "hrw",
      hwext: "true",
      hwqe : "true",
      hwre : "true",
      fields : [
        {
          bits: "31:0"
          name: "counter_value"
          desc: '''
                Counter value of perf_op_is_tcr_mrr performance counter. Clear automatically on read when LPDDR_PERF_CLEAR_ON_READ is high.
                '''
        }
      ]
    },
    { 
      name: "LPDDR_PERF_OP_IS_WR_COUNT",
      desc : "Performance counting register that indicates the perf_op_is_wr count since the previous read (clear on read).",
      swaccess : "rc",
      hwaccess : "hrw",
      hwext: "true",
      hwqe : "true",
      hwre : "true",
      fields : [
        {
          bits: "31:0"
          name: "counter_value"
          desc: '''
                Counter value of perf_op_is_wr performance counter. Clear automatically on read when LPDDR_PERF_CLEAR_ON_READ is high.
                '''
        }
      ]
    },
    { 
      name: "LPDDR_PERF_OP_IS_ZQLATCH_COUNT",
      desc : "Performance counting register that indicates the perf_op_is_zqlatch count since the previous read (clear on read).",
      swaccess : "rc",
      hwaccess : "hrw",
      hwext: "true",
      hwqe : "true",
      hwre : "true",
      fields : [
        {
          bits: "31:0"
          name: "counter_value"
          desc: '''
                Counter value of perf_op_is_zqlatch performance counter. Clear automatically on read when LPDDR_PERF_CLEAR_ON_READ is high.
                '''
        }
      ]
    },
    { 
      name: "LPDDR_PERF_OP_IS_ZQSTART_COUNT",
      desc : "Performance counting register that indicates the perf_op_is_zqstart count since the previous read (clear on read).",
      swaccess : "rc",
      hwaccess : "hrw",
      hwext: "true",
      hwqe : "true",
      hwre : "true",
      fields : [
        {
          bits: "31:0"
          name: "counter_value"
          desc: '''
                Counter value of perf_op_is_zqstart performance counter. Clear automatically on read when LPDDR_PERF_CLEAR_ON_READ is high.
                '''
        }
      ]
    },
    { 
      name: "LPDDR_PERF_PRECHARGE_FOR_OTHER_COUNT",
      desc : "Performance counting register that indicates the perf_precharge_for_other count since the previous read (clear on read).",
      swaccess : "rc",
      hwaccess : "hrw",
      hwext: "true",
      hwqe : "true",
      hwre : "true",
      fields : [
        {
          bits: "31:0"
          name: "counter_value"
          desc: '''
                Counter value of perf_precharge_for_other performance counter. Clear automatically on read when LPDDR_PERF_CLEAR_ON_READ is high.
                '''
        }
      ]
    },
    { 
      name: "LPDDR_PERF_PRECHARGE_FOR_RDWR_COUNT",
      desc : "Performance counting register that indicates the perf_precharge_for_rdwr count since the previous read (clear on read).",
      swaccess : "rc",
      hwaccess : "hrw",
      hwext: "true",
      hwqe : "true",
      hwre : "true",
      fields : [
        {
          bits: "31:0"
          name: "counter_value"
          desc: '''
                Counter value of perf_precharge_for_rdwr performance counter. Clear automatically on read when LPDDR_PERF_CLEAR_ON_READ is high.
                '''
        }
      ]
    },
    { 
      name: "LPDDR_PERF_RAW_HAZARD_COUNT",
      desc : "Performance counting register that indicates the perf_raw_hazard count since the previous read (clear on read).",
      swaccess : "rc",
      hwaccess : "hrw",
      hwext: "true",
      hwqe : "true",
      hwre : "true",
      fields : [
        {
          bits: "31:0"
          name: "counter_value"
          desc: '''
                Counter value of perf_raw_hazard performance counter. Clear automatically on read when LPDDR_PERF_CLEAR_ON_READ is high.
                '''
        }
      ]
    },
    { 
      name: "LPDDR_PERF_RDWR_TRANSITIONS_COUNT",
      desc : "Performance counting register that indicates the perf_rdwr_transitions count since the previous read (clear on read).",
      swaccess : "rc",
      hwaccess : "hrw",
      hwext: "true",
      hwqe : "true",
      hwre : "true",
      fields : [
        {
          bits: "31:0"
          name: "counter_value"
          desc: '''
                Counter value of perf_rdwr_transitions performance counter. Clear automatically on read when LPDDR_PERF_CLEAR_ON_READ is high.
                '''
        }
      ]
    },
    { 
      name: "LPDDR_PERF_SELFREF_MODE_RANK_0_COUNT",
      desc : "Performance counting register that indicates the perf_selfref_mode_rank_0 count since the previous read (clear on read).",
      swaccess : "rc",
      hwaccess : "hrw",
      hwext: "true",
      hwqe : "true",
      hwre : "true",
      fields : [
        {
          bits: "31:0"
          name: "counter_value"
          desc: '''
                Counter value of perf_selfref_mode_rank_0 performance counter. Clear automatically on read when LPDDR_PERF_CLEAR_ON_READ is high.
                '''
        }
      ]
    },
    { 
      name: "LPDDR_PERF_SELFREF_MODE_RANK_1_COUNT",
      desc : "Performance counting register that indicates the perf_selfref_mode_rank_1 count since the previous read (clear on read).",
      swaccess : "rc",
      hwaccess : "hrw",
      hwext: "true",
      hwqe : "true",
      hwre : "true",
      fields : [
        {
          bits: "31:0"
          name: "counter_value"
          desc: '''
                Counter value of perf_selfref_mode_rank_1 performance counter. Clear automatically on read when LPDDR_PERF_CLEAR_ON_READ is high.
                '''
        }
      ]
    },
    { 
      name: "LPDDR_PERF_VISIBLE_WINDOW_LIMIT_REACHED_RD_COUNT",
      desc : "Performance counting register that indicates the perf_visible_window_limit_reached_rd count since the previous read (clear on read).",
      swaccess : "rc",
      hwaccess : "hrw",
      hwext: "true",
      hwqe : "true",
      hwre : "true",
      fields : [
        {
          bits: "31:0"
          name: "counter_value"
          desc: '''
                Counter value of perf_visible_window_limit_reached_rd performance counter. Clear automatically on read when LPDDR_PERF_CLEAR_ON_READ is high.
                '''
        }
      ]
    },
    { 
      name: "LPDDR_PERF_VISIBLE_WINDOW_LIMIT_REACHED_WR_COUNT",
      desc : "Performance counting register that indicates the perf_visible_window_limit_reached_wr count since the previous read (clear on read).",
      swaccess : "rc",
      hwaccess : "hrw",
      hwext: "true",
      hwqe : "true",
      hwre : "true",
      fields : [
        {
          bits: "31:0"
          name: "counter_value"
          desc: '''
                Counter value of perf_visible_window_limit_reached_wr performance counter. Clear automatically on read when LPDDR_PERF_CLEAR_ON_READ is high.
                '''
        }
      ]
    },
    { 
      name: "LPDDR_PERF_WAR_HAZARD_COUNT",
      desc : "Performance counting register that indicates the perf_war_hazard count since the previous read (clear on read).",
      swaccess : "rc",
      hwaccess : "hrw",
      hwext: "true",
      hwqe : "true",
      hwre : "true",
      fields : [
        {
          bits: "31:0"
          name: "counter_value"
          desc: '''
                Counter value of perf_war_hazard performance counter. Clear automatically on read when LPDDR_PERF_CLEAR_ON_READ is high.
                '''
        }
      ]
    },
    { 
      name: "LPDDR_PERF_WAW_HAZARD_COUNT",
      desc : "Performance counting register that indicates the perf_waw_hazard count since the previous read (clear on read).",
      swaccess : "rc",
      hwaccess : "hrw",
      hwext: "true",
      hwqe : "true",
      hwre : "true",
      fields : [
        {
          bits: "31:0"
          name: "counter_value"
          desc: '''
                Counter value of perf_waw_hazard performance counter. Clear automatically on read when LPDDR_PERF_CLEAR_ON_READ is high.
                '''
        }
      ]
    },
    { 
      name: "LPDDR_PERF_WR_XACT_WHEN_CRITICAL_COUNT",
      desc : "Performance counting register that indicates the perf_wr_xact_when_critical count since the previous read (clear on read).",
      swaccess : "rc",
      hwaccess : "hrw",
      hwext: "true",
      hwqe : "true",
      hwre : "true",
      fields : [
        {
          bits: "31:0"
          name: "counter_value"
          desc: '''
                Counter value of perf_wr_xact_when_critical performance counter. Clear automatically on read when LPDDR_PERF_CLEAR_ON_READ is high.
                '''
        }
      ]
    },
    { 
      name: "LPDDR_PERF_WRITE_COMBINE_COUNT",
      desc : "Performance counting register that indicates the perf_write_combine count since the previous read (clear on read).",
      swaccess : "rc",
      hwaccess : "hrw",
      hwext: "true",
      hwqe : "true",
      hwre : "true",
      fields : [
        {
          bits: "31:0"
          name: "counter_value"
          desc: '''
                Counter value of perf_write_combine performance counter. Clear automatically on read when LPDDR_PERF_CLEAR_ON_READ is high.
                '''
        }
      ]
    },
    { 
      name: "LPDDR_PERF_WRITE_COMBINE_NOECC_COUNT",
      desc : "Performance counting register that indicates the perf_write_combine_noecc count since the previous read (clear on read).",
      swaccess : "rc",
      hwaccess : "hrw",
      hwext: "true",
      hwqe : "true",
      hwre : "true",
      fields : [
        {
          bits: "31:0"
          name: "counter_value"
          desc: '''
                Counter value of perf_write_combine_noecc performance counter. Clear automatically on read when LPDDR_PERF_CLEAR_ON_READ is high.
                '''
        }
      ]
    },
    { 
      name: "LPDDR_PERF_WRITE_COMBINE_WRECC_COUNT",
      desc : "Performance counting register that indicates the perf_write_combine_wrecc count since the previous read (clear on read).",
      swaccess : "rc",
      hwaccess : "hrw",
      hwext: "true",
      hwqe : "true",
      hwre : "true",
      fields : [
        {
          bits: "31:0"
          name: "counter_value"
          desc: '''
                Counter value of perf_write_combine_wrecc performance counter. Clear automatically on read when LPDDR_PERF_CLEAR_ON_READ is high.
                '''
        }
      ]
    },
    { 
      name: "LPDDR_RAQ_SPLIT_COUNT",
      desc : "Performance counting register that indicates the raq_split count since the previous read (clear on read).",
      swaccess : "rc",
      hwaccess : "hrw",
      hwext: "true",
      hwqe : "true",
      hwre : "true",
      fields : [
        {
          bits: "31:0"
          name: "counter_value"
          desc: '''
                Counter value of raq_split performance counter. Clear automatically on read when LPDDR_PERF_CLEAR_ON_READ is high.
                '''
        }
      ]
    },
    { 
      name: "LPDDR_RAQB_POP_COUNT",
      desc : "Performance counting register that indicates the raqb_pop count since the previous read (clear on read).",
      swaccess : "rc",
      hwaccess : "hrw",
      hwext: "true",
      hwqe : "true",
      hwre : "true",
      fields : [
        {
          bits: "31:0"
          name: "counter_value"
          desc: '''
                Counter value of raqb_pop performance counter. Clear automatically on read when LPDDR_PERF_CLEAR_ON_READ is high.
                '''
        }
      ]
    },
    { 
      name: "LPDDR_RAQB_PUSH_COUNT",
      desc : "Performance counting register that indicates the raqb_push count since the previous read (clear on read).",
      swaccess : "rc",
      hwaccess : "hrw",
      hwext: "true",
      hwqe : "true",
      hwre : "true",
      fields : [
        {
          bits: "31:0"
          name: "counter_value"
          desc: '''
                Counter value of raqb_push performance counter. Clear automatically on read when LPDDR_PERF_CLEAR_ON_READ is high.
                '''
        }
      ]
    },
    { 
      name: "LPDDR_RAQR_POP_COUNT",
      desc : "Performance counting register that indicates the raqr_pop count since the previous read (clear on read).",
      swaccess : "rc",
      hwaccess : "hrw",
      hwext: "true",
      hwqe : "true",
      hwre : "true",
      fields : [
        {
          bits: "31:0"
          name: "counter_value"
          desc: '''
                Counter value of raqr_pop performance counter. Clear automatically on read when LPDDR_PERF_CLEAR_ON_READ is high.
                '''
        }
      ]
    },
    { 
      name: "LPDDR_RAQR_PUSH_COUNT",
      desc : "Performance counting register that indicates the raqr_push count since the previous read (clear on read).",
      swaccess : "rc",
      hwaccess : "hrw",
      hwext: "true",
      hwqe : "true",
      hwre : "true",
      fields : [
        {
          bits: "31:0"
          name: "counter_value"
          desc: '''
                Counter value of raqr_push performance counter. Clear automatically on read when LPDDR_PERF_CLEAR_ON_READ is high.
                '''
        }
      ]
    },
    { 
      name: "LPDDR_WAQ_POP_COUNT",
      desc : "Performance counting register that indicates the waq_pop count since the previous read (clear on read).",
      swaccess : "rc",
      hwaccess : "hrw",
      hwext: "true",
      hwqe : "true",
      hwre : "true",
      fields : [
        {
          bits: "31:0"
          name: "counter_value"
          desc: '''
                Counter value of waq_pop performance counter. Clear automatically on read when LPDDR_PERF_CLEAR_ON_READ is high.
                '''
        }
      ]
    },
    { 
      name: "LPDDR_WAQ_PUSH_COUNT",
      desc : "Performance counting register that indicates the waq_push count since the previous read (clear on read).",
      swaccess : "rc",
      hwaccess : "hrw",
      hwext: "true",
      hwqe : "true",
      hwre : "true",
      fields : [
        {
          bits: "31:0"
          name: "counter_value"
          desc: '''
                Counter value of waq_push performance counter. Clear automatically on read when LPDDR_PERF_CLEAR_ON_READ is high.
                '''
        }
      ]
    },
    { 
      name: "LPDDR_WAQ_SPLIT_COUNT",
      desc : "Performance counting register that indicates the waq_split count since the previous read (clear on read).",
      swaccess : "rc",
      hwaccess : "hrw",
      hwext: "true",
      hwqe : "true",
      hwre : "true",
      fields : [
        {
          bits: "31:0"
          name: "counter_value"
          desc: '''
                Counter value of waq_split performance counter. Clear automatically on read when LPDDR_PERF_CLEAR_ON_READ is high.
                '''
        }
      ]
    },
  ]
}
