// (C) Copyright 2024 Axelera AI B.V.
// All Rights Reserved
// *** Axelera AI Confidential ***
//
// Owner: Milos Stanisavljevic <milos.stanisavljevic@axelera.ai>
//
// Description: hjson desc for pcie_csr reg

// Copyright lowRISC contributors.
// Licensed under the Apache License, Version 2.0, see LICENSE for details.
// SPDX-License-Identifier: Apache-2.0
{ name: "pcie_csr",
  clocking: [{clock: "clk_i", reset: "rst_ni"}],
  bus_interfaces: [{protocol: "tlul", direction: "device"}],
  regwidth: "32",
  addrcap: "0x10000",
  axi_intf: False
  param_list : []
  registers: [
    { skipto: "0x200" },
    { name: "PERST_N"
      desc: "Control signal for perst_n"
      swaccess: "rw"
      hwaccess: "hro"
      fields: [
        {
          name: "perst_n"
          bits: "0"
          resval: 1
          desc: '''
                Used to apply PERST# to PCIE subsystem.
                '''
        }
      ]
    }
    { name: "MSI_INT"
      desc: "Control signal for i_msi_int"
      swaccess: "rw"
      hwaccess: "hro"
      fields: [
        {
          name: "i_msi_int"
          bits: "31:0"
          resval: 0
          desc: '''
                Used to raise msi_int to PCIE subsystem.
                '''
        }
      ]
    }
    { name: "SYS_INT"
      desc: "Control signal for i_sys_int"
      swaccess: "rw"
      hwaccess: "hro"
      fields: [
        {
          name: "i_sys_int"
          bits: "0"
          resval: 0
          desc: '''
                Used to raise sys_int to PCIE subsystem.
                '''
        }
      ]
    }
    { name: "CLKREQ_CONTROL"
      desc: "Control signal for clkreq_in_n"
      swaccess: "rw"
      hwaccess: "hro"
      fields: [
        {
          name: "clkreq_in_n"
          bits: "0"
          resval: 1
          desc: '''
                Used to assert CLKREQ to PCIE subsystem.
                '''
        }
      ]
    }
    { name: "OBS_CONTROL"
      desc: "Control mux selecting observation signals"
      swaccess: "rw"
      hwaccess: "hro"
      fields: [
        {
          name: "obs_ctrl"
          bits: "1:0"
          resval: 0
          desc: '''
                00: select pcie_dbg_signal
                01: select phy0_dtb_out
                10: select output clocks and reset
                '''
        }
      ]
    }
    { name: "LOCAL_REFCLK_REQ_STATUS"
      desc: "Check the status of the local REFCLK request"
      swaccess: "ro"
      hwaccess: "hwo"
      fields: [
        {
          name: "local_ref_clk_req_n"
          bits: "0"
          resval: 1
          desc: '''
                Local REFCLK request status.
                '''
        }
      ]
    }
    { name: "RST_STATUS"
      desc: "Check the status of AXI resets"
      swaccess: "ro"
      hwaccess: "hwo"
      fields: [
        {
          name: "o_core_rst_n"
          bits: "0"
          resval: 1
          desc: '''
                PCIe CTRL core reset status.
                '''
        }
        {
          name: "o_pwr_rst_n"
          bits: "1"
          resval: 1
          desc: '''
                PCIe subsystem reset status.
                '''
        }
        {
          name: "o_mstr_aresetn"
          bits: "2"
          resval: 1
          desc: '''
                AXI M reset status.
                '''
        }
        {
          name: "o_slv_aresetn"
          bits: "3"
          resval: 1
          desc: '''
                AXI S reset status.
                '''
        }
        {
          name: "o_dbi_aresetn"
          bits: "4"
          resval: 1
          desc: '''
                AXI DBI reset status.
                '''
        }
      ]
    }
  ]
}
