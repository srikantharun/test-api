{ name: "apu_ao_csr"
  clocking: [{clock: "clk_i", reset: "rst_ni"}]
  bus_interfaces: [
    { protocol: "tlul", direction: "device" }
  ]
  regwidth: "32"
  addrcap: "0x1000"
  axi_intf: False
  param_list : [
    {name:"AW", type:"int", default:"16"}
    {name:"PR1_NB_MONITOR", type:"int", default:"14"}
    {name:"PR2_NB_MONITOR", type:"int", default:"43"}
    {name:"SVS_NB_MONITOR", type:"int", default:"30"}
  ]
  registers: [
    { skipto: "0x200" }
    { multireg : {
      name: "APU_CORE_RESET_VECTOR_LOW"
      desc: "Select low part of reset_vector for core"
      count: "6"
      cname: "APU_CORE_RESET_VECTOR_LOW"
      swaccess: "rw"
      hwaccess: "hro"
      fields: [
        {
          bits: "31:0"
          name: "reset_vector_low"
          desc: '''
                reset_vector lower part 31:0
                It should normally be a 4-byte aligned value but a 2-byte aligned value is also allowed; bit 0 should be zero.
                Default to bootrom start address.
                '''
          resval: 0x10000
        }
      ]
    }}
    { multireg : {
      name: "APU_CORE_RESET_VECTOR_HIGH"
      desc: "Select high part of reset_vector for core"
      count: "6"
      cname: "APU_CORE_RESET_VECTOR_HIGH"
      swaccess: "rw"
      hwaccess: "hro"
      fields: [
        {
          bits: "15:0"
          name: "reset_vector_high"
          desc: '''
                reset_vector higher part 47:32
                '''
          resval: 0x0
        }
      ]
    }}

    { multireg : {
      name: "APU_CORE_MEM_POWER_MODE"
      desc: "Control Register to select the power mode of the APU core memory."
      count: "6"
      cname: "APU_CORE_MEM_POWER_MODE"
      swaccess: "rw"
      hwaccess: "hro"
      fields: [
        {
          bits: "0"
          name: "ret"
          desc: '''
                Retention mode enable, active high
                When PDE is high and RET are low, the memory operates in the power-down mode.
                However, when PDE is high and RET is high, you can control the retention voltage of the core by varying VDDCE.
                '''
          resval: 0x0
        }
        {
          bits: "1"
          name: "pde"
          desc: '''
                Power down enable, active high
                During normal SRAM operation, this signal must be low to enable power gates.
                When high, the retention mode or power-down mode is enable.
                '''
          resval: 0x0
        }
      ]
    }}
    { multireg : {
      name: "APU_CORE_MEM_POWER_UP_READY"
      desc: "Status Register that indicates the Ready for Operation of the APU core memory."
      count: "6"
      cname: "APU_CORE_MEM_POWER_UP_READY"
      swaccess: "ro"
      hwaccess: "hwo"
      hwext: "true"
      fields: [
        {
          bits: "0"
          name:"prn"
          desc: '''
                Power up ready negative
                When entering normal mode from power mode, PRN is changed from 1 to 0 to notify that power up is completed.
                '''
        }
      ]
    }}

    { name: "APU_L2C_MEM_POWER_MODE"
      desc: "Control Register to select the power mode of the APU L2C memory."
      swaccess: "rw"
      hwaccess: "hro"
      fields: [
        {
          bits: "0"
          name: "ret"
          desc: '''
                Retention mode enable, active high
                When PDE is high and RET are low, the memory operates in the power-down mode.
                However, when PDE is high and RET is high, you can control the retention voltage of the core by varying VDDCE.
                '''
          resval: 0x0
        }
        {
          bits: "1"
          name: "pde"
          desc: '''
                Power down enable, active high
                During normal SRAM operation, this signal must be low to enable power gates.
                When high, the retention mode or power-down mode is enable.
                '''
          resval: 0x0
        }
      ]
    }
    { name: "APU_L2C_MEM_POWER_UP_READY"
      desc: "Status Register that indicates the Ready for Operation of the APU L2C memory."
      swaccess: "ro"
      hwaccess: "hwo"
      hwext: "true"
      fields: [
        {
          bits: "0"
          name:"prn"
          desc: '''
                Power up ready negative
                When entering normal mode from power mode, PRN is changed from 1 to 0 to notify that power up is completed.
                '''
        }
      ]
    }

    { name: "APU_DMA_MEM_POWER_MODE"
      desc: "Control Register to select the power mode of the APU DMA memory."
      swaccess: "rw"
      hwaccess: "hro"
      fields: [
        {
          bits: "0"
          name: "ret"
          desc: '''
                Retention mode enable, active high
                When PDE is high and RET are low, the memory operates in the power-down mode.
                However, when PDE is high and RET is high, you can control the retention voltage of the core by varying VDDCE.
                '''
          resval: 0x0
        }
        {
          bits: "1"
          name: "pde"
          desc: '''
                Power down enable, active high
                During normal SRAM operation, this signal must be low to enable power gates.
                When high, the retention mode or power-down mode is enable.
                '''
          resval: 0x0
        }
      ]
    }
    { name: "APU_DMA_MEM_POWER_UP_READY"
      desc: "Status Register that indicates the Ready for Operation of the APU DMA memory."
      swaccess: "ro"
      hwaccess: "hwo"
      hwext: "true"
      fields: [
        {
          bits: "0"
          name:"prn"
          desc: '''
                Power up ready negative
                When entering normal mode from power mode, PRN is changed from 1 to 0 to notify that power up is completed.
                '''
        }
      ]
    }

    { name: "APU_ROM_MEM_POWER_MODE"
      desc: "Control Register to select the power mode of the APU ROM memory."
      swaccess: "rw"
      hwaccess: "hro"
      fields: [
        {
          bits: "0"
          name: "pde"
          desc: '''
                Power down enable, active high
                During normal ROM operation, this signal must be low to enable power gates.
                When high, the retention mode or power-down mode is enable.
                '''
          resval: 0x0
        }
      ]
    }
    { name: "APU_ROM_MEM_POWER_UP_READY"
      desc: "Status Register that indicates the Ready for Operation of the APU ROM memory."
      swaccess: "ro"
      hwaccess: "hwo"
      hwext: "true"
      fields: [
        {
          bits: "0"
          name:"prn"
          desc: '''
                Power up ready negative
                When entering normal mode from power mode, PRN is changed from 1 to 0 to notify that power up is completed.
                '''
        }
      ]
    }

    { multireg : {
      name: "APU_CORE_DISABLE_INIT"
      desc: "Control Register to disable APU core memory initialization."
      count: "6"
      cname: "APU_CORE_DISABLE_INIT"
      swaccess: "rw"
      hwaccess: "hro"
      fields: [
        {
          bits: "0"
          name: "disable_init"
          desc: '''
                Disable initialization, active high
                Disable the initialization of D-Cache and I-Cache RAMs when the processor exits the reset state.
                Asserting this signal speeds up the power-gating wake-up process when the content of D-Cache and I-Cache SRAM is preserved during power-down.
                '''
          resval: 0x0
        }
      ]
    }}
    { name: "APU_L2C_DISABLE_INIT"
      desc: "Control Register to disable the APU L2C memory initialization."
      swaccess: "rw"
      hwaccess: "hro"
      fields: [
        {
          bits: "0"
          name: "disable_init"
          desc: '''
                Disable initialization, active high
                Disable the initialization of L2C RAMs when the L2C exits the reset state.
                Asserting this signal speeds up the power-gating wake-up process when the content of L2C SRAM is preserved during power-down.
                '''
          resval: 0x0
        }
      ]
    }

    { name: "P1_CONTROL"
      desc: "Control signals for P1 Monitor"
      swaccess: "rw"
      hwaccess: "hro"
      fields: [
        {
          name: "enable"
          bits: "0"
          resval: 0
          desc: '''
                0: initialises the macro
                1: starts measurement
                Must stay at 1 until measurement has completed.
                '''
        }
        {
          name: "target"
          bits: "3:1"
          resval: 0
          desc: '''
                Measure during `2**target` ref_clk cycles.
                '''
        }
      ]
    }
    { multireg: { name: "P1_RO_SELECT"
      count: "PR1_NB_MONITOR"
      cname: "p1cntid"
      compact: false
      desc: "Bit-mask indicating which ring oscillators to use. Use[k]=0: do not use RO k."
      swaccess: "rw"
      hwaccess: "hro"
      fields: [
        {
          name: "use_ro"
          bits: "0"
          resval: 0
          desc: '''
                Bit-mask indicating which ring oscillators to use. Use[k]=0: do not use RO k.
                '''
        }
      ]
    }}
    { multireg: {name: "P1_COUNTERS"
      count: "PR1_NB_MONITOR"
      cname: "p1cntid"
      compact: false
      desc: "Measure results per counter"
      swaccess: "ro"
      hwaccess: "hrw"
      fields: [
        {
            bits: "15:0"
            name: "count"
            resval: 0
            desc: '''
                  Measurement result for RO with index k
                  X whenever valid=0
                  0 if use[k] was 0 when starting the measurement
                  '''
        }
      ]
    }}
    { name: "P2_CONTROL"
      desc: "Control signals for P2 Monitor"
      swaccess: "rw"
      hwaccess: "hro"
      fields: [
        {
          name: "enable"
          bits: "0"
          resval: 0
          desc: '''
                0: initialises the macro
                1: starts measurement
                Must stay at 1 until measurement has completed.
                '''
        }
        {
          name: "target"
          bits: "3:1"
          resval: 0
          desc: '''
                Measure during `2**target` ref_clk cycles.
                '''
        }
      ]
    }
    { multireg: { name: "P2_RO_SELECT"
      count: "PR2_NB_MONITOR"
      cname: "p2cntid"
      compact: false
      desc: "Bit-mask indicating which ring oscillators to use. Use[k]=0: do not use RO k."
      swaccess: "rw"
      hwaccess: "hro"
      fields: [
        {
          name: "use_ro"
          bits: "0"
          resval: 0
          desc: '''
                Bit-mask indicating which ring oscillators to use. Use[k]=0: do not use RO k.
                '''
        }
      ]
    }}
    { multireg: {name: "P2_COUNTERS"
      count: "PR2_NB_MONITOR"
      cname: "p2cntid"
      compact: false
      desc: "Measure results per counter"
      swaccess: "ro"
      hwaccess: "hrw"
      fields: [
        {
            bits: "15:0"
            name: "count"
            resval: 0
            desc: '''
                  Measurement result for RO with index k
                  X whenever valid=0
                  0 if use[k] was 0 when starting the measurement
                  '''
        }
      ]
    }}
    { name: "SVS_CONTROL"
      desc: "Control signals for SVS Core Monitor"
      swaccess: "rw"
      hwaccess: "hro"
      fields: [
        {
          name: "enable"
          bits: "0"
          resval: 0
          desc: '''
                0: initialises the macro
                1: starts measurement
                Must stay at 1 until measurement has completed.
                '''
        }
        {
          name: "target"
          bits: "3:1"
          resval: 0
          desc: '''
                Measure during `2**target` ref_clk cycles.
                '''
        }
      ]
    }
    { name: "SVS_RO_SELECT"
      desc: "Bit-mask indicating which ring oscillators to use. Use[k]=0: do not use RO k."
      swaccess: "rw"
      hwaccess: "hro"
      fields: [
        {
          name: "use_ro"
          bits: "29:0"
          resval: 0
          desc: '''
                Bit-mask indicating which ring oscillators to use. Use[k]=0: do not use RO k.
                '''
        }
      ]
    }
    { multireg: {name: "SVS_COUNTERS"
      count: "SVS_NB_MONITOR"
      cname: "svscntid"
      compact: false
      desc: "Measure results per counter"
      swaccess: "ro"
      hwaccess: "hrw"
      fields: [
        {
            bits: "15:0"
            name: "count"
            resval: 0
            desc: '''
                  Measurement result for RO with index k
                  X whenever valid=0
                  0 if use[k] was 0 when starting the measurement
                  '''
        }
      ]
    }}

    ######################
    ## LowPower Control ##
    ######################
    { name: "FABRIC_LOW_POWER_CONTROL"
      desc: "Low Power control for the fabric"
      swaccess: "rw"
      hwaccess: "hro"
      fields: [
        {
            bits: "0"
            name: "ENABLE"
            resval: 0x1
            desc: '''
                  Low Power enable for the fabric
                  '''
        }
        {
            bits: "15:8"
            name: "IDLE_DELAY"
            resval: 0x8
            desc: '''
                  Delay going to a low power state for `IDLE_DELAY` amount of cycles
                  '''
        }
      ]
    }
  ]
}
